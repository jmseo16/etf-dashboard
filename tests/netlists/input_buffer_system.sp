.SUBCKT CTLE INP INN OUTP OUTN VBIAS VDD VSS
RLP VDD OUTP 600
RLN VDD OUTN 600
M1 OUTP INP SP VSS NCH W=16u L=45n
M2 OUTN INN SN VSS NCH W=16u L=45n
RS SP SN 1000
CS SP SN 150f
MBP SP VBIAS VSS VSS NCH W=32u L=90n
MBN SN VBIAS VSS VSS NCH W=32u L=90n
.ENDS CTLE

.SUBCKT CML_LATCH DP DN CLK CLKB QP QN VBIAS VDD VSS
RLP VDD QP 500
RLN VDD QN 500
M1 QP DP TAIL_T VSS NCH W=12u L=45n
M2 QN DN TAIL_T VSS NCH W=12u L=45n
M3 QP QN TAIL_H VSS NCH W=12u L=45n
M4 QN QP TAIL_H VSS NCH W=12u L=45n
M5 TAIL_T CLK TAIL VSS NCH W=16u L=45n
M6 TAIL_H CLKB TAIL VSS NCH W=16u L=45n
MB TAIL VBIAS VSS VSS NCH W=32u L=90n
.ENDS CML_LATCH

.SUBCKT CML_DFF DP DN CLK CLKB QP QN VBIAS VDD VSS
X_MASTER DP DN CLKB CLK MP MN VBIAS VDD VSS CML_LATCH
X_SLAVE MP MN CLK CLKB QP QN VBIAS VDD VSS CML_LATCH
.ENDS CML_DFF

.SUBCKT DFE_1TAP INP INN CLK CLKB OUTP OUTN VBIAS_MAIN VBIAS_TAP VBIAS_DFF VDD VSS
RLP VDD SUMP 500
RLN VDD SUMN 500
M1 SUMP INP TAIL_M VSS NCH W=20u L=45n
M2 SUMN INN TAIL_M VSS NCH W=20u L=45n
MB_M TAIL_M VBIAS_MAIN VSS VSS NCH W=40u L=90n
M3 SUMP OUTP TAIL_T1 VSS NCH W=8u L=45n
M4 SUMN OUTN TAIL_T1 VSS NCH W=8u L=45n
MB_T1 TAIL_T1 VBIAS_TAP VSS VSS NCH W=16u L=90n
X_DFF SUMP SUMN CLK CLKB OUTP OUTN VBIAS_DFF VDD VSS CML_DFF
.ENDS DFE_1TAP

.SUBCKT INPUT_BUFFER_SYSTEM RX_INP RX_INN CLK CLKB DOUTP DOUTN VBIAS_CTLE VBIAS_MAIN VBIAS_TAP VBIAS_DFF VDD VSS
X_CTLE RX_INP RX_INN CTLE_OUTP CTLE_OUTN VBIAS_CTLE VDD VSS CTLE
X_DFE CTLE_OUTP CTLE_OUTN CLK CLKB DOUTP DOUTN VBIAS_MAIN VBIAS_TAP VBIAS_DFF VDD VSS DFE_1TAP
.ENDS INPUT_BUFFER_SYSTEM
