.SUBCKT INV A Y VDD VSS
MP Y A VDD VDD PCH W=2u L=45n
MN Y A VSS VSS NCH W=1u L=45n
.ENDS INV

.SUBCKT NAND2 A B Y VDD VSS
MP1 Y A VDD VDD PCH W=2u L=45n
MP2 Y B VDD VDD PCH W=2u L=45n
MN1 Y A MID VSS NCH W=2u L=45n
MN2 MID B VSS VSS NCH W=2u L=45n
.ENDS NAND2

.SUBCKT SR_LATCH SB RB Q QB VDD VSS
X1 SB QB Q VDD VSS NAND2
X2 RB Q QB VDD VSS NAND2
.ENDS SR_LATCH

.SUBCKT STRONGARM_SLICER INP INN CLK QP QN VDD VSS
M_TAIL TAIL CLK VSS VSS NCH W=16u L=45n
M1 DP INP TAIL VSS NCH W=12u L=45n
M2 DN INN TAIL VSS NCH W=12u L=45n
M3 OUTP OUTN DP VSS NCH W=8u L=45n
M4 OUTN OUTP DN VSS NCH W=8u L=45n
M5 OUTP OUTN VDD VDD PCH W=8u L=45n
M6 OUTN OUTP VDD VDD PCH W=8u L=45n
M7 DP CLK VDD VDD PCH W=4u L=45n
M8 DN CLK VDD VDD PCH W=4u L=45n
M9 OUTP CLK VDD VDD PCH W=4u L=45n
M10 OUTN CLK VDD VDD PCH W=4u L=45n
M11 DP DN VDD VDD PCH W=2u L=45n
X_SR OUTP OUTN QP QN VDD VSS SR_LATCH
X_BUFP QP QPB VDD VSS INV
X_BUFN QN QNB VDD VSS INV
.ENDS STRONGARM_SLICER

.SUBCKT CML_LATCH DP DN CLK CLKB QP QN VBN VDD VSS
MP_LP QP VSS VDD VDD PCH W=8u L=45n
MP_LN QN VSS VDD VDD PCH W=8u L=45n
M1 QP DP TAIL_T VSS NCH W=12u L=45n
M2 QN DN TAIL_T VSS NCH W=12u L=45n
M3 QP QN TAIL_H VSS NCH W=10u L=45n
M4 QN QP TAIL_H VSS NCH W=10u L=45n
M5 TAIL_T CLK TAIL VSS NCH W=16u L=45n
M6 TAIL_H CLKB TAIL VSS NCH W=16u L=45n
MB TAIL VBN VSS VSS NCH W=32u L=90n
.ENDS CML_LATCH

.SUBCKT CML_DFF DP DN CLK CLKB QP QN VBN VDD VSS
X_M DP DN CLKB CLK MP MN VBN VDD VSS CML_LATCH
X_S MP MN CLK CLKB QP QN VBN VDD VSS CML_LATCH
.ENDS CML_DFF

.SUBCKT IDAC_4BIT B0 B1 B2 B3 VBN IOUT VDD VSS
MB0 T0 VBN VSS VSS NCH W=4u L=90n
MS0 IOUT B0 T0 VSS NCH W=4u L=45n
MB1 T1 VBN VSS VSS NCH W=8u L=90n
MS1 IOUT B1 T1 VSS NCH W=8u L=45n
MB2 T2 VBN VSS VSS NCH W=16u L=90n
MS2 IOUT B2 T2 VSS NCH W=16u L=45n
MB3 T3 VBN VSS VSS NCH W=32u L=90n
MS3 IOUT B3 T3 VSS NCH W=32u L=45n
.ENDS IDAC_4BIT

.SUBCKT CTLE_STAGE INP INN OUTP OUTN VBN VBP C0 C1 C2 R0 R1 R2 VDD VSS
MP_LP OUTP VBP VDD VDD PCH W=24u L=45n
MP_LN OUTN VBP VDD VDD PCH W=24u L=45n
M_IND_P OUTP G_IND_P VDD VDD NCH W=8u L=45n
M_IND_N OUTN G_IND_N VDD VDD NCH W=8u L=45n
R_IND_P VDD G_IND_P 2000
R_IND_N VDD G_IND_N 2000
M1 OUTP INP SP VSS NCH W=24u L=45n
M2 OUTN INN SN VSS NCH W=24u L=45n
MBP SP VBN VSS VSS NCH W=32u L=90n
MBN SN VBN VSS VSS NCH W=32u L=90n
R_DEG_BASE SP SN 800
MR0 SP R0 SN VSS NCH W=4u L=45n
MR1 SP R1 SN VSS NCH W=8u L=45n
MR2 SP R2 SN VSS NCH W=16u L=45n
C_DEG_BASE SP SN 50f
MC0P SP C0 C0_MID VSS NCH W=8u L=45n
MC0N C0_MID C0 SN VSS NCH W=8u L=45n
C0_CAP SP SN 40f
MC1P SP C1 C1_MID VSS NCH W=16u L=45n
MC1N C1_MID C1 SN VSS NCH W=16u L=45n
C1_CAP SP SN 80f
MC2P SP C2 C2_MID VSS NCH W=32u L=45n
MC2N C2_MID C2 SN VSS NCH W=32u L=45n
C2_CAP SP SN 160f
.ENDS CTLE_STAGE

.SUBCKT VGA_STAGE INP INN OUTP OUTN VBN VBP G0 G1 G2 G3 VDD VSS
MP_LP OUTP VBP VDD VDD PCH W=32u L=45n
MP_LN OUTN VBP VDD VDD PCH W=32u L=45n
M_MAIN_P OUTP INP TAIL_M VSS NCH W=16u L=45n
M_MAIN_N OUTN INN TAIL_M VSS NCH W=16u L=45n
MB_M TAIL_M VBN VSS VSS NCH W=24u L=90n
M_G0_P OUTP INP T_G0 VSS NCH W=4u L=45n
M_G0_N OUTN INN T_G0 VSS NCH W=4u L=45n
MS_G0 T_G0 G0 B_G0 VSS NCH W=4u L=45n
MB_G0 B_G0 VBN VSS VSS NCH W=6u L=90n
M_G1_P OUTP INP T_G1 VSS NCH W=8u L=45n
M_G1_N OUTN INN T_G1 VSS NCH W=8u L=45n
MS_G1 T_G1 G1 B_G1 VSS NCH W=8u L=45n
MB_G1 B_G1 VBN VSS VSS NCH W=12u L=90n
M_G2_P OUTP INP T_G2 VSS NCH W=16u L=45n
M_G2_N OUTN INN T_G2 VSS NCH W=16u L=45n
MS_G2 T_G2 G2 B_G2 VSS NCH W=16u L=45n
MB_G2 B_G2 VBN VSS VSS NCH W=24u L=90n
M_G3_P OUTP INP T_G3 VSS NCH W=32u L=45n
M_G3_N OUTN INN T_G3 VSS NCH W=32u L=45n
MS_G3 T_G3 G3 B_G3 VSS NCH W=32u L=45n
MB_G3 B_G3 VBN VSS VSS NCH W=48u L=90n
.ENDS VGA_STAGE

.SUBCKT DFE_SUMMER INP INN T1P T1N T2P T2N T3P T3N T4P T4N OUTP OUTN VBN VBP
+ W1_0 W1_1 W1_2 W1_3 W2_0 W2_1 W2_2 W2_3 W3_0 W3_1 W3_2 W3_3 W4_0 W4_1 W4_2 W4_3 VDD VSS
MP_LP OUTP VBP VDD VDD PCH W=48u L=45n
MP_LN OUTN VBP VDD VDD PCH W=48u L=45n
M_MP OUTP INP TAIL_M VSS NCH W=32u L=45n
M_MN OUTN INN TAIL_M VSS NCH W=32u L=45n
MB_M TAIL_M VBN VSS VSS NCH W=64u L=90n
M_T1P OUTP T1P TAIL_T1 VSS NCH W=16u L=45n
M_T1N OUTN T1N TAIL_T1 VSS NCH W=16u L=45n
X_DAC1 W1_0 W1_1 W1_2 W1_3 VBN TAIL_T1 VDD VSS IDAC_4BIT
M_T2P OUTP T2P TAIL_T2 VSS NCH W=12u L=45n
M_T2N OUTN T2N TAIL_T2 VSS NCH W=12u L=45n
X_DAC2 W2_0 W2_1 W2_2 W2_3 VBN TAIL_T2 VDD VSS IDAC_4BIT
M_T3P OUTP T3P TAIL_T3 VSS NCH W=8u L=45n
M_T3N OUTN T3N TAIL_T3 VSS NCH W=8u L=45n
X_DAC3 W3_0 W3_1 W3_2 W3_3 VBN TAIL_T3 VDD VSS IDAC_4BIT
M_T4P OUTP T4P TAIL_T4 VSS NCH W=6u L=45n
M_T4N OUTN T4N TAIL_T4 VSS NCH W=6u L=45n
X_DAC4 W4_0 W4_1 W4_2 W4_3 VBN TAIL_T4 VDD VSS IDAC_4BIT
.ENDS DFE_SUMMER

.SUBCKT HALF_RATE_DFE_SLICE INP INN CLK CLKB D_OUTP D_OUTN
+ T2_INP T2_INN T3_INP T3_INN T4_INP T4_INN
+ T1_FB_P T1_FB_N T2_OUTP T2_OUTN T3_OUTP T3_OUTN
+ VBN VBP
+ W1_0 W1_1 W1_2 W1_3 W2_0 W2_1 W2_2 W2_3 W3_0 W3_1 W3_2 W3_3 W4_0 W4_1 W4_2 W4_3 VDD VSS
X_SUM INP INN T1_FB_P T1_FB_N T2_INP T2_INN T3_INP T3_INN T4_INP T4_INN SUMP SUMN VBN VBP
+ W1_0 W1_1 W1_2 W1_3 W2_0 W2_1 W2_2 W2_3 W3_0 W3_1 W3_2 W3_3 W4_0 W4_1 W4_2 W4_3 VDD VSS DFE_SUMMER
X_SLICER SUMP SUMN CLK SA_QP SA_QN VDD VSS STRONGARM_SLICER
X_LATCH1 SA_QP SA_QN CLK CLKB D_OUTP D_OUTN VBN VDD VSS CML_LATCH
X_DFF2 D_OUTP D_OUTN CLK CLKB T2_OUTP T2_OUTN VBN VDD VSS CML_DFF
X_DFF3 T2_OUTP T2_OUTN CLK CLKB T3_OUTP T3_OUTN VBN VDD VSS CML_DFF
.ENDS HALF_RATE_DFE_SLICE

.SUBCKT CLK_DIST_TREE CLK_INP CLK_INN CLKI CLKIB CLKQ CLKQB VBN VDD VSS
R_TERM_P CLK_INP VCM_CLK 50
R_TERM_N CLK_INN VCM_CLK 50
C_VCM VCM_CLK VSS 1p
MP_B1P B1P VSS VDD VDD PCH W=16u L=45n
MP_B1N B1N VSS VDD VDD PCH W=16u L=45n
MN_B1P B1P CLK_INP T_B1 VSS NCH W=24u L=45n
MN_B1N B1N CLK_INN T_B1 VSS NCH W=24u L=45n
MB_B1 T_B1 VBN VSS VSS NCH W=48u L=90n
X_DIV_M B1N B1P B1P B1N CLKI CLKIB VBN VDD VSS CML_LATCH
X_DIV_S CLKI CLKIB B1N B1P CLKQ CLKQB VBN VDD VSS CML_LATCH
X_INV_I1 CLKI CLKI_B1 VDD VSS INV
X_INV_I2 CLKI_B1 CLKI_BUF VDD VSS INV
X_INV_IB1 CLKIB CLKIB_B1 VDD VSS INV
X_INV_IB2 CLKIB_B1 CLKIB_BUF VDD VSS INV
X_INV_Q1 CLKQ CLKQ_B1 VDD VSS INV
X_INV_Q2 CLKQ_B1 CLKQ_BUF VDD VSS INV
X_INV_QB1 CLKQB CLKQB_B1 VDD VSS INV
X_INV_QB2 CLKQB_B1 CLKQB_BUF VDD VSS INV
.ENDS CLK_DIST_TREE

.SUBCKT BIAS_GEN IREF_IN VBN VBP VDD VSS
M_NREF IREF_IN IREF_IN VSS VSS NCH W=16u L=90n
M_NMIR VBP IREF_IN VSS VSS NCH W=16u L=90n
M_PREF VBP VBP VDD VDD PCH W=32u L=90n
M_PMIR VBN VBP VDD VDD PCH W=32u L=90n
M_NLOAD VBN VBN VSS VSS NCH W=16u L=90n
C_DECAP_N VBN VSS 500f
C_DECAP_P VBP VDD 500f
.ENDS BIAS_GEN

.SUBCKT RX_AFE_TOP RX_INP RX_INN CLK_INP CLK_INN IREF
+ DOUT_EVEN_P DOUT_EVEN_N DOUT_ODD_P DOUT_ODD_N
+ C0 C1 C2 R0 R1 R2 G0 G1 G2 G3
+ W1_0 W1_1 W1_2 W1_3 W2_0 W2_1 W2_2 W2_3 W3_0 W3_1 W3_2 W3_3 W4_0 W4_1 W4_2 W4_3
+ VDD VSS
R_RX_P RX_INP VCM_RX 50
R_RX_N RX_INN VCM_RX 50
C_RX_VCM VCM_RX VSS 2p
M_ESD_P1 RX_INP VDD VDD VDD PCH W=40u L=45n
M_ESD_N1 RX_INP VSS VSS VSS NCH W=40u L=45n
M_ESD_P2 RX_INN VDD VDD VDD PCH W=40u L=45n
M_ESD_N2 RX_INN VSS VSS VSS NCH W=40u L=45n

X_BIAS IREF VBN VBP VDD VSS BIAS_GEN
X_CLK CLK_INP CLK_INN CLKI CLKIB CLKQ CLKQB VBN VDD VSS CLK_DIST_TREE

X_CTLE1 RX_INP RX_INN CTLE1_P CTLE1_N VBN VBP C0 C1 C2 R0 R1 R2 VDD VSS CTLE_STAGE
X_CTLE2 CTLE1_P CTLE1_N CTLE2_P CTLE2_N VBN VBP C0 C1 C2 R0 R1 R2 VDD VSS CTLE_STAGE
X_VGA CTLE2_P CTLE2_N VGA_P VGA_N VBN VBP G0 G1 G2 G3 VDD VSS VGA_STAGE

X_DFE_EVEN VGA_P VGA_N CLKI CLKIB DOUT_EVEN_P DOUT_EVEN_N
+ E_T2P E_T2N O_T2P O_T2N E_T3P E_T3N
+ O_DOUTP O_DOUTN E_T2P E_T2N E_T3P E_T3N
+ VBN VBP
+ W1_0 W1_1 W1_2 W1_3 W2_0 W2_1 W2_2 W2_3 W3_0 W3_1 W3_2 W3_3 W4_0 W4_1 W4_2 W4_3 VDD VSS HALF_RATE_DFE_SLICE

X_DFE_ODD VGA_P VGA_N CLKIB CLKI DOUT_ODD_P DOUT_ODD_N
+ O_T2P O_T2N E_T2P E_T2N O_T3P O_T3N
+ DOUT_EVEN_P DOUT_EVEN_N O_T2P O_T2N O_T3P O_T3N
+ VBN VBP
+ W1_0 W1_1 W1_2 W1_3 W2_0 W2_1 W2_2 W2_3 W3_0 W3_1 W3_2 W3_3 W4_0 W4_1 W4_2 W4_3 VDD VSS HALF_RATE_DFE_SLICE

M_TIE_P O_DOUTP VSS DOUT_ODD_P VSS NCH W=16u L=45n
M_TIE_P2 O_DOUTP VDD DOUT_ODD_P VDD PCH W=16u L=45n
M_TIE_N O_DOUTN VSS DOUT_ODD_N VSS NCH W=16u L=45n
M_TIE_N2 O_DOUTN VDD DOUT_ODD_N VDD PCH W=16u L=45n
.ENDS RX_AFE_TOP
