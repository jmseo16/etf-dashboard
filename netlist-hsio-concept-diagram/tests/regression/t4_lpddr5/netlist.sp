** Generated for: hspiceD
** Generated on: Nov 15 10:41:07 2026
** Design library name: LP5IO_TOP
** Design cell name: LP5_DQ_BYTE
** Design view name: schematic

.TEMP 25.0
.OPTION ARTIST=2 INGOLD=2 PARHIER=LOCAL PSF=2

.MODEL NCH     NMOS LEVEL=54 VERSION=4.5 VTH0=0.35  TOXE=1.4n
.MODEL PCH     PMOS LEVEL=54 VERSION=4.5 VTH0=-0.35 TOXE=1.4n
.MODEL NCH_LVT NMOS LEVEL=54 VERSION=4.5 VTH0=0.25  TOXE=1.4n
.MODEL PCH_LVT PMOS LEVEL=54 VERSION=4.5 VTH0=-0.25 TOXE=1.4n
.MODEL NCH_IO  NMOS LEVEL=54 VERSION=4.5 VTH0=0.50  TOXE=3.2n
.MODEL PCH_IO  PMOS LEVEL=54 VERSION=4.5 VTH0=-0.50 TOXE=3.2n

** Library name: LP5IO_STD
** Cell name: INV_D1
** View name: schematic
.SUBCKT INV_D1 A Y VDD VSS
M_N0 Y A VSS VSS NCH W=0.2u L=0.04u M=1
M_P0 Y A VDD VDD PCH W=0.4u L=0.04u M=1
.ENDS INV_D1
** End of subcircuit definition.

** Library name: LP5IO_STD
** Cell name: INV_D4
** View name: schematic
.SUBCKT INV_D4 A Y VDD VSS
M_N0 Y A VSS VSS NCH_LVT W=0.8u L=0.04u M=1
M_P0 Y A VDD VDD PCH_LVT W=1.6u L=0.04u M=1
.ENDS INV_D4
** End of subcircuit definition.

** Library name: LP5IO_STD
** Cell name: NAND2_D1
** View name: schematic
.SUBCKT NAND2_D1 A B Y VDD VSS
M_N0 Y A NS VSS NCH W=0.4u L=0.04u M=1
M_N1 NS B VSS VSS NCH W=0.4u L=0.04u M=1
M_P0 Y A VDD VDD PCH W=0.4u L=0.04u M=1
M_P1 Y B VDD VDD PCH W=0.4u L=0.04u M=1
.ENDS NAND2_D1
** End of subcircuit definition.

** Library name: LP5IO_STD
** Cell name: NAND3_D1
** View name: schematic
.SUBCKT NAND3_D1 A B C Y VDD VSS
M_N0 Y A NS1 VSS NCH W=0.6u L=0.04u M=1
M_N1 NS1 B NS2 VSS NCH W=0.6u L=0.04u M=1
M_N2 NS2 C VSS VSS NCH W=0.6u L=0.04u M=1
M_P0 Y A VDD VDD PCH W=0.4u L=0.04u M=1
M_P1 Y B VDD VDD PCH W=0.4u L=0.04u M=1
M_P2 Y C VDD VDD PCH W=0.4u L=0.04u M=1
.ENDS NAND3_D1
** End of subcircuit definition.

** Library name: LP5IO_STD
** Cell name: NOR2_D1
** View name: schematic
.SUBCKT NOR2_D1 A B Y VDD VSS
M_N0 Y A VSS VSS NCH W=0.2u L=0.04u M=1
M_N1 Y B VSS VSS NCH W=0.2u L=0.04u M=1
M_P0 PS A VDD VDD PCH W=0.8u L=0.04u M=1
M_P1 Y B PS VDD PCH W=0.8u L=0.04u M=1
.ENDS NOR2_D1
** End of subcircuit definition.

** Library name: LP5IO_STD
** Cell name: TGMUX2
** View name: schematic
.SUBCKT TGMUX2 D0 D1 S SB Y VDD VSS
M_N0 Y SB D0 VSS NCH W=0.3u L=0.04u M=1
M_P0 Y S D0 VDD PCH W=0.3u L=0.04u M=1
M_N1 Y S D1 VSS NCH W=0.3u L=0.04u M=1
M_P1 Y SB D1 VDD PCH W=0.3u L=0.04u M=1
.ENDS TGMUX2
** End of subcircuit definition.

** Library name: LP5IO_STD
** Cell name: DFF_TSPC
** View name: schematic
.SUBCKT DFF_TSPC D CK Q QB VDD VSS
M_P1 N1 D VDD VDD PCH_LVT W=0.6u L=0.04u M=1
M_P2 X1 CK N1 VDD PCH_LVT W=0.6u L=0.04u M=1
M_N1 X1 D VSS VSS NCH_LVT W=0.3u L=0.04u M=1
M_P3 Y1 CK VDD VDD PCH_LVT W=0.4u L=0.04u M=1
M_N2 Y1 X1 N2 VSS NCH_LVT W=0.4u L=0.04u M=1
M_N3 N2 CK VSS VSS NCH_LVT W=0.4u L=0.04u M=1
M_P4 QB Y1 VDD VDD PCH_LVT W=0.6u L=0.04u M=1
M_N4 QB CK N3 VSS NCH_LVT W=0.4u L=0.04u M=1
M_N5 N3 Y1 VSS VSS NCH_LVT W=0.4u L=0.04u M=1
M_N6 Q QB VSS VSS NCH_LVT W=0.3u L=0.04u M=1
M_P6 Q QB VDD VDD PCH_LVT W=0.6u L=0.04u M=1
.ENDS DFF_TSPC
** End of subcircuit definition.

** Library name: LP5IO_TX
** Cell name: SER_MUX4
** View name: schematic
.SUBCKT SER_MUX4 D[3] D[2] D[1] D[0] P[3] P[2] P[1] P[0] Y VDD VSS
M_ND0 Y D[0] NA0 VSS NCH_LVT W=0.6u L=0.04u M=1
M_NC0 NA0 P[0] NB0 VSS NCH_LVT W=0.6u L=0.04u M=1
M_NE0 NB0 P[3] VSS VSS NCH_LVT W=0.6u L=0.04u M=1
M_PD0 Y D[0] PA0 VDD PCH_LVT W=1u L=0.04u M=1
M_PC0 PA0 P[2] PB0 VDD PCH_LVT W=1u L=0.04u M=1
M_PE0 PB0 P[1] VDD VDD PCH_LVT W=1u L=0.04u M=1
M_ND1 Y D[1] NA1 VSS NCH_LVT W=0.6u L=0.04u M=1
M_NC1 NA1 P[1] NB1 VSS NCH_LVT W=0.6u L=0.04u M=1
M_NE1 NB1 P[0] VSS VSS NCH_LVT W=0.6u L=0.04u M=1
M_PD1 Y D[1] PA1 VDD PCH_LVT W=1u L=0.04u M=1
M_PC1 PA1 P[3] PB1 VDD PCH_LVT W=1u L=0.04u M=1
M_PE1 PB1 P[2] VDD VDD PCH_LVT W=1u L=0.04u M=1
M_ND2 Y D[2] NA2 VSS NCH_LVT W=0.6u L=0.04u M=1
M_NC2 NA2 P[2] NB2 VSS NCH_LVT W=0.6u L=0.04u M=1
M_NE2 NB2 P[1] VSS VSS NCH_LVT W=0.6u L=0.04u M=1
M_PD2 Y D[2] PA2 VDD PCH_LVT W=1u L=0.04u M=1
M_PC2 PA2 P[0] PB2 VDD PCH_LVT W=1u L=0.04u M=1
M_PE2 PB2 P[3] VDD VDD PCH_LVT W=1u L=0.04u M=1
M_ND3 Y D[3] NA3 VSS NCH_LVT W=0.6u L=0.04u M=1
M_NC3 NA3 P[3] NB3 VSS NCH_LVT W=0.6u L=0.04u M=1
M_NE3 NB3 P[2] VSS VSS NCH_LVT W=0.6u L=0.04u M=1
M_PD3 Y D[3] PA3 VDD PCH_LVT W=1u L=0.04u M=1
M_PC3 PA3 P[1] PB3 VDD PCH_LVT W=1u L=0.04u M=1
M_PE3 PB3 P[0] VDD VDD PCH_LVT W=1u L=0.04u M=1
.ENDS SER_MUX4
** End of subcircuit definition.

** Library name: LP5IO_TX
** Cell name: SLEW_INV
** View name: schematic
.SUBCKT SLEW_INV A Y SR[1] SR[0] SRB[1] SRB[0] VDD VSS
M_PB Y A VDD VDD PCH_LVT W=1u L=0.04u M=1
M_NB Y A VSS VSS NCH_LVT W=0.5u L=0.04u M=1
M_P0E PS0 SRB[0] VDD VDD PCH_LVT W=1u L=0.04u M=1
M_P0 Y A PS0 VDD PCH_LVT W=1u L=0.04u M=1
M_N0 Y A NS0 VSS NCH_LVT W=0.5u L=0.04u M=1
M_N0E NS0 SR[0] VSS VSS NCH_LVT W=0.5u L=0.04u M=1
M_P1E PS1 SRB[1] VDD VDD PCH_LVT W=2u L=0.04u M=1
M_P1 Y A PS1 VDD PCH_LVT W=2u L=0.04u M=1
M_N1 Y A NS1 VSS NCH_LVT W=1u L=0.04u M=1
M_N1E NS1 SR[1] VSS VSS NCH_LVT W=1u L=0.04u M=1
.ENDS SLEW_INV
** End of subcircuit definition.

** Library name: LP5IO_TX
** Cell name: TX_PDRV
** View name: schematic
.SUBCKT TX_PDRV D P SR[1] SR[0] SRB[1] SRB[0] PUG_M PDG_M PUG_P PDG_P VDD VSS
M_DIN DB D VSS VSS NCH_LVT W=0.4u L=0.04u M=1
M_DIP DB D VDD VDD PCH_LVT W=0.8u L=0.04u M=1
X_SPU DB PUG_M SR[1] SR[0] SRB[1] SRB[0] VDD VSS SLEW_INV
X_SPD D PDG_M SR[1] SR[0] SRB[1] SRB[0] VDD VSS SLEW_INV
M_PIN PDG_P P VSS VSS NCH_LVT W=0.4u L=0.04u M=1
M_PIP PDG_P P VDD VDD PCH_LVT W=0.8u L=0.04u M=1
M_QUN PUG_P PDG_P VSS VSS NCH_LVT W=0.4u L=0.04u M=1
M_QUP PUG_P PDG_P VDD VDD PCH_LVT W=0.8u L=0.04u M=1
.ENDS TX_PDRV
** End of subcircuit definition.

** Library name: LP5IO_TX
** Cell name: TX_LEG_M
** View name: schematic
.SUBCKT TX_LEG_M PUG PDG EN PAD VDDQ VSSQ
M_PUE VDDQ EN NU1 VSSQ NCH W=2.4u L=0.04u M=1
M_PU NU1 PUG NU2 VSSQ NCH W=2.4u L=0.04u M=1
R_PU NU2 PAD 300
R_PD PAD ND2 300
M_PD ND2 PDG ND1 VSSQ NCH W=2.4u L=0.04u M=1
M_PDE ND1 EN VSSQ VSSQ NCH W=2.4u L=0.04u M=1
.ENDS TX_LEG_M
** End of subcircuit definition.

** Library name: LP5IO_TX
** Cell name: TX_LEG_P
** View name: schematic
.SUBCKT TX_LEG_P PUG PDG EN PAD VDDQ VSSQ
M_PUE VDDQ EN NU1 VSSQ NCH W=0.6u L=0.04u M=1
M_PU NU1 PUG NU2 VSSQ NCH W=0.6u L=0.04u M=1
R_PU NU2 PAD 1200
R_PD PAD ND2 1200
M_PD ND2 PDG ND1 VSSQ NCH W=0.6u L=0.04u M=1
M_PDE ND1 EN VSSQ VSSQ NCH W=0.6u L=0.04u M=1
.ENDS TX_LEG_P
** End of subcircuit definition.

** Library name: LP5IO_TX
** Cell name: TX_DRV
** View name: schematic
.SUBCKT TX_DRV PUG_M PDG_M PUG_P PDG_P EN_M[4] EN_M[3] EN_M[2] EN_M[1] EN_M[0] EN_P[2]
+ EN_P[1] EN_P[0] PAD VDDQ VSSQ
X_LM4 PUG_M PDG_M EN_M[4] PAD VDDQ VSSQ TX_LEG_M M=16
X_LM3 PUG_M PDG_M EN_M[3] PAD VDDQ VSSQ TX_LEG_M M=8
X_LM2 PUG_M PDG_M EN_M[2] PAD VDDQ VSSQ TX_LEG_M M=4
X_LM1 PUG_M PDG_M EN_M[1] PAD VDDQ VSSQ TX_LEG_M M=2
X_LM0 PUG_M PDG_M EN_M[0] PAD VDDQ VSSQ TX_LEG_M M=1
X_LP2 PUG_P PDG_P EN_P[2] PAD VDDQ VSSQ TX_LEG_P M=16
X_LP1 PUG_P PDG_P EN_P[1] PAD VDDQ VSSQ TX_LEG_P M=8
X_LP0 PUG_P PDG_P EN_P[0] PAD VDDQ VSSQ TX_LEG_P M=4
.ENDS TX_DRV
** End of subcircuit definition.

** Library name: LP5IO_TX
** Cell name: TX_SER4
** View name: schematic
.SUBCKT TX_SER4 TXD[3] TXD[2] TXD[1] TXD[0] PH[3] PH[2] PH[1] PH[0] DS PS VDD VSS
X_FF0 TXD[0] PH[3] B0 B0B VDD VSS DFF_TSPC
X_FF1 TXD[1] PH[3] B1 B1B VDD VSS DFF_TSPC
X_FF2 TXD[2] PH[0] B2 B2B VDD VSS DFF_TSPC
X_FF3 TXD[3] PH[1] B3 B3B VDD VSS DFF_TSPC
X_MUXM B3B B2B B1B B0B PH[3] PH[2] PH[1] PH[0] DS VDD VSS SER_MUX4
X_MUXP B2 B1 B0 B3 PH[3] PH[2] PH[1] PH[0] PS VDD VSS SER_MUX4
.ENDS TX_SER4
** End of subcircuit definition.

** Library name: LP5IO_TX
** Cell name: TX_DQ
** View name: schematic
.SUBCKT TX_DQ TXD[3] TXD[2] TXD[1] TXD[0] PH[3] PH[2] PH[1] PH[0] SR[1] SR[0] SRB[1]
+ SRB[0] EN_M[4] EN_M[3] EN_M[2] EN_M[1] EN_M[0] EN_P[2] EN_P[1] EN_P[0] PAD VDD VSS
+ VDDQ VSSQ
X_SER TXD[3] TXD[2] TXD[1] TXD[0] PH[3] PH[2] PH[1] PH[0] DS PS VDD VSS TX_SER4
X_PDRV DS PS SR[1] SR[0] SRB[1] SRB[0] PUG_M PDG_M PUG_P PDG_P VDD VSS TX_PDRV
X_DRV PUG_M PDG_M PUG_P PDG_P EN_M[4] EN_M[3] EN_M[2] EN_M[1] EN_M[0] EN_P[2] EN_P[1]
+ EN_P[0] PAD VDDQ VSSQ TX_DRV
.ENDS TX_DQ
** End of subcircuit definition.

** Library name: LP5IO_TX
** Cell name: TX_CTRL
** View name: schematic
.SUBCKT TX_CTRL ZC[4] ZC[3] ZC[2] ZC[1] ZC[0] OE EQ_EN SR[1] SR[0] EN_M[4] EN_M[3]
+ EN_M[2] EN_M[1] EN_M[0] EN_P[2] EN_P[1] EN_P[0] SRB[1] SRB[0] VDD VSS
X_NM4 ZC[4] OE EMB4 VDD VSS NAND2_D1
X_IM4 EMB4 EN_M[4] VDD VSS INV_D1
X_NM3 ZC[3] OE EMB3 VDD VSS NAND2_D1
X_IM3 EMB3 EN_M[3] VDD VSS INV_D1
X_NM2 ZC[2] OE EMB2 VDD VSS NAND2_D1
X_IM2 EMB2 EN_M[2] VDD VSS INV_D1
X_NM1 ZC[1] OE EMB1 VDD VSS NAND2_D1
X_IM1 EMB1 EN_M[1] VDD VSS INV_D1
X_NM0 ZC[0] OE EMB0 VDD VSS NAND2_D1
X_IM0 EMB0 EN_M[0] VDD VSS INV_D1
X_NP2 EN_M[4] EQ_EN EPB2 VDD VSS NAND2_D1
X_IP2 EPB2 EN_P[2] VDD VSS INV_D1
X_NP1 EN_M[3] EQ_EN EPB1 VDD VSS NAND2_D1
X_IP1 EPB1 EN_P[1] VDD VSS INV_D1
X_NP0 EN_M[2] EQ_EN EPB0 VDD VSS NAND2_D1
X_IP0 EPB0 EN_P[0] VDD VSS INV_D1
X_SR1 SR[1] SRB[1] VDD VSS INV_D1
X_SR0 SR[0] SRB[0] VDD VSS INV_D1
.ENDS TX_CTRL
** End of subcircuit definition.

** Library name: LP5IO_ODT
** Cell name: ODT_LEG
** View name: schematic
.SUBCKT ODT_LEG G PAD VSSQ
R_ODT PAD NO 600
M_ODT NO G VSSQ VSSQ NCH W=2u L=0.04u M=1
.ENDS ODT_LEG
** End of subcircuit definition.

** Library name: LP5IO_ODT
** Cell name: ODT_PD
** View name: schematic
.SUBCKT ODT_PD G[2] G[1] G[0] PAD VSSQ
X_OL2 G[2] PAD VSSQ ODT_LEG M=4
X_OL1 G[1] PAD VSSQ ODT_LEG M=2
X_OL0 G[0] PAD VSSQ ODT_LEG M=1
.ENDS ODT_PD
** End of subcircuit definition.

** Library name: LP5IO_ODT
** Cell name: ODT_CTRL
** View name: schematic
.SUBCKT ODT_CTRL ODT_EN ODT_C[2] ODT_C[1] ODT_C[0] OE ODT_G[2] ODT_G[1] ODT_G[0] VDD VSS
X_OEI OE OEB VDD VSS INV_D1
X_NO2 ODT_C[2] ODT_EN OEB OGB2 VDD VSS NAND3_D1
X_IO2 OGB2 ODT_G[2] VDD VSS INV_D1
X_NO1 ODT_C[1] ODT_EN OEB OGB1 VDD VSS NAND3_D1
X_IO1 OGB1 ODT_G[1] VDD VSS INV_D1
X_NO0 ODT_C[0] ODT_EN OEB OGB0 VDD VSS NAND3_D1
X_IO0 OGB0 ODT_G[0] VDD VSS INV_D1
.ENDS ODT_CTRL
** End of subcircuit definition.

** Library name: LP5IO_RX
** Cell name: CTLE_SC
** View name: schematic
.SUBCKT CTLE_SC INP INN VBP C[1] C[0] OUTP OUTN VDD VSS
M_TA SA VBP VDD VDD PCH W=4u L=0.1u M=1
M_TB SB VBP VDD VDD PCH W=4u L=0.1u M=1
M_IA OUTN INP SA VDD PCH_LVT W=4u L=0.04u M=1
M_IB OUTP INN SB VDD PCH_LVT W=4u L=0.04u M=1
R_LA OUTN VSS 1.5k
R_LB OUTP VSS 1.5k
R_S SA SB 800
C_A0 SA CX0 40f
M_S0 CX0 C[0] CY0 VSS NCH_LVT W=1u L=0.04u M=1
C_B0 CY0 SB 40f
C_A1 SA CX1 80f
M_S1 CX1 C[1] CY1 VSS NCH_LVT W=2u L=0.04u M=1
C_B1 CY1 SB 80f
.ENDS CTLE_SC
** End of subcircuit definition.

** Library name: LP5IO_RX
** Cell name: DT_CMP
** View name: schematic
.SUBCKT DT_CMP INP INN CK CKB VA VTRN VTRP OUTP OUTN VDD VSS
M_T1 TL1 CK VSS VSS NCH_LVT W=1u L=0.04u M=1
M_I1 FN INP TL1 VSS NCH_LVT W=0.8u L=0.04u M=1
M_I2 FP INN TL1 VSS NCH_LVT W=0.8u L=0.04u M=1
M_PC1 FN CK VDD VDD PCH_LVT W=0.4u L=0.04u M=1
M_PC2 FP CK VDD VDD PCH_LVT W=0.4u L=0.04u M=1
M_AL FP VA TL1 VSS NCH W=0.1u L=0.1u M=1
M_TN FN VTRN TL1 VSS NCH W=0.1u L=0.1u M=1
M_TP FP VTRP TL1 VSS NCH W=0.1u L=0.1u M=1
M_T2 TL2 CKB VDD VDD PCH_LVT W=1.2u L=0.04u M=1
M_LP1 OUTP OUTN TL2 VDD PCH_LVT W=0.6u L=0.04u M=1
M_LP2 OUTN OUTP TL2 VDD PCH_LVT W=0.6u L=0.04u M=1
M_LN1 OUTP OUTN VSS VSS NCH_LVT W=0.4u L=0.04u M=1
M_LN2 OUTN OUTP VSS VSS NCH_LVT W=0.4u L=0.04u M=1
M_R1 OUTP FN VSS VSS NCH_LVT W=0.6u L=0.04u M=1
M_R2 OUTN FP VSS VSS NCH_LVT W=0.6u L=0.04u M=1
.ENDS DT_CMP
** End of subcircuit definition.

** Library name: LP5IO_RX
** Cell name: DFE_MUXLAT
** View name: schematic
.SUBCKT DFE_MUXLAT SH RH SL RL S SB D DB VDD VSS
M_P1 D DB VDD VDD PCH_LVT W=0.15u L=0.06u M=1
M_N1 D DB VSS VSS NCH_LVT W=0.15u L=0.06u M=1
M_P2 DB D VDD VDD PCH_LVT W=0.15u L=0.06u M=1
M_N2 DB D VSS VSS NCH_LVT W=0.15u L=0.06u M=1
M_S1 DB SH XS1 VSS NCH_LVT W=0.8u L=0.04u M=1
M_S2 XS1 S VSS VSS NCH_LVT W=0.8u L=0.04u M=1
M_S3 DB SL XS2 VSS NCH_LVT W=0.8u L=0.04u M=1
M_S4 XS2 SB VSS VSS NCH_LVT W=0.8u L=0.04u M=1
M_R1 D RH XR1 VSS NCH_LVT W=0.8u L=0.04u M=1
M_R2 XR1 S VSS VSS NCH_LVT W=0.8u L=0.04u M=1
M_R3 D RL XR2 VSS NCH_LVT W=0.8u L=0.04u M=1
M_R4 XR2 SB VSS VSS NCH_LVT W=0.8u L=0.04u M=1
.ENDS DFE_MUXLAT
** End of subcircuit definition.

** Library name: LP5IO_RX
** Cell name: RX_PHASE
** View name: schematic
.SUBCKT RX_PHASE INP INN CK CKB VA VTRN VTRP SEL SELB D DB VDD VSS
X_CMPH INP INN CK CKB VA VTRN VTRP HP HN VDD VSS DT_CMP
X_CMPL INN INP CK CKB VA VTRP VTRN LN LP VDD VSS DT_CMP
X_MXL HP HN LP LN SEL SELB D DB VDD VSS DFE_MUXLAT
.ENDS RX_PHASE
** End of subcircuit definition.

** Library name: LP5IO_RX
** Cell name: RX_TRIM_DAC
** View name: schematic
.SUBCKT RX_TRIM_DAC C[2] C[1] C[0] CB[2] CB[1] CB[0] VBP VTRN VTRP VDD VSS
M_CS2 NS2 VBP VDD VDD PCH W=0.5u L=0.2u M=4
M_SN2 VTRN CB[2] NS2 VDD PCH W=0.5u L=0.04u M=4
M_SP2 VTRP C[2] NS2 VDD PCH W=0.5u L=0.04u M=4
M_CS1 NS1 VBP VDD VDD PCH W=0.5u L=0.2u M=2
M_SN1 VTRN CB[1] NS1 VDD PCH W=0.5u L=0.04u M=2
M_SP1 VTRP C[1] NS1 VDD PCH W=0.5u L=0.04u M=2
M_CS0 NS0 VBP VDD VDD PCH W=0.5u L=0.2u M=1
M_SN0 VTRN CB[0] NS0 VDD PCH W=0.5u L=0.04u M=1
M_SP0 VTRP C[0] NS0 VDD PCH W=0.5u L=0.04u M=1
M_DN VTRN VTRN VSS VSS NCH W=1u L=0.1u M=1
M_DP VTRP VTRP VSS VSS NCH W=1u L=0.1u M=1
.ENDS RX_TRIM_DAC
** End of subcircuit definition.

** Library name: LP5IO_RX
** Cell name: RX_CAL_CNT
** View name: schematic
.SUBCKT RX_CAL_CNT UP UPB EN CK C[2] C[1] C[0] CB[2] CB[1] CB[0] VDD VSS
X_PM2 UPB UP C[2] CB[2] PJ2 VDD VSS TGMUX2
X_PM1 UPB UP C[1] CB[1] PJ1 VDD VSS TGMUX2
X_PM0 UPB UP C[0] CB[0] PJ0 VDD VSS TGMUX2
X_SAT PJ0 PJ1 PJ2 ALLPB VDD VSS NAND3_D1
X_GE EN ALLPB G0B VDD VSS NAND2_D1
X_GEI G0B G0 VDD VSS INV_D1
X_G1 G0 PJ0 G1B VDD VSS NAND2_D1
X_G1I G1B G1 VDD VSS INV_D1
X_G2 G1 PJ1 G2B VDD VSS NAND2_D1
X_G2I G2B G2 VDD VSS INV_D1
X_TM2 G2 G2B C[2] CB[2] DN2 VDD VSS TGMUX2
X_TM1 G1 G1B C[1] CB[1] DN1 VDD VSS TGMUX2
X_TM0 G0 G0B C[0] CB[0] DN0 VDD VSS TGMUX2
X_FF2 DN2 CK C[2] CB[2] VDD VSS DFF_TSPC
X_FF1 DN1 CK C[1] CB[1] VDD VSS DFF_TSPC
X_FF0 DN0 CK C[0] CB[0] VDD VSS DFF_TSPC
.ENDS RX_CAL_CNT
** End of subcircuit definition.

** Library name: LP5IO_RX
** Cell name: RX_DQ
** View name: schematic
.SUBCKT RX_DQ PADR VREF CAL_EN CAL_ENB PH[3] PH[2] PH[1] PH[0] CTLE_C[1] CTLE_C[0] VBP
+ VALF CAL_CK CAL_RUN RXD[3] RXD[2] RXD[1] RXD[0] VDD VSS
M_ISO PADR CAL_ENB RXIN VSS NCH_LVT W=4u L=0.04u M=1
M_CSN RXIN CAL_EN VREF VSS NCH W=0.5u L=0.04u M=1
M_CSP RXIN CAL_ENB VREF VDD PCH W=0.5u L=0.04u M=1
X_CTLE RXIN VREF VBP CTLE_C[1] CTLE_C[0] CTP CTN VDD VSS CTLE_SC
X_PH0 CTP CTN PH[0] PH[2] VALF VTRN VTRP RXD[3] DB3 RXD[0] DB0 VDD VSS RX_PHASE
X_PH1 CTP CTN PH[1] PH[3] VALF VTRN VTRP RXD[0] DB0 RXD[1] DB1 VDD VSS RX_PHASE
X_PH2 CTP CTN PH[2] PH[0] VALF VTRN VTRP RXD[1] DB1 RXD[2] DB2 VDD VSS RX_PHASE
X_PH3 CTP CTN PH[3] PH[1] VALF VTRN VTRP RXD[2] DB2 RXD[3] DB3 VDD VSS RX_PHASE
X_TDAC TC[2] TC[1] TC[0] TCB[2] TCB[1] TCB[0] VBP VTRN VTRP VDD VSS RX_TRIM_DAC
X_CNT DB0 RXD[0] CAL_RUN CAL_CK TC[2] TC[1] TC[0] TCB[2] TCB[1] TCB[0] VDD VSS
+ RX_CAL_CNT
.ENDS RX_DQ
** End of subcircuit definition.

** Library name: LP5IO_RX
** Cell name: TAP_DAC
** View name: schematic
.SUBCKT TAP_DAC TAP[2] TAP[1] TAP[0] CAL_ENB VBP VALF VDD VSS
X_TN2 TAP[2] CAL_ENB TB2 VDD VSS NAND2_D1
M_CS2 NT2 VBP VDD VDD PCH W=0.5u L=0.2u M=4
M_SW2 VALF TB2 NT2 VDD PCH W=0.5u L=0.04u M=4
X_TN1 TAP[1] CAL_ENB TB1 VDD VSS NAND2_D1
M_CS1 NT1 VBP VDD VDD PCH W=0.5u L=0.2u M=2
M_SW1 VALF TB1 NT1 VDD PCH W=0.5u L=0.04u M=2
X_TN0 TAP[0] CAL_ENB TB0 VDD VSS NAND2_D1
M_CS0 NT0 VBP VDD VDD PCH W=0.5u L=0.2u M=1
M_SW0 VALF TB0 NT0 VDD PCH W=0.5u L=0.04u M=1
M_D VALF VALF VSS VSS NCH W=1u L=0.1u M=1
.ENDS TAP_DAC
** End of subcircuit definition.

** Library name: LP5IO_REF
** Cell name: VREF_R2R
** View name: schematic
.SUBCKT VREF_R2R CODE[3] CODE[2] CODE[1] CODE[0] EN VREF VDD VSS VDDQ VSSQ
R_T1 VDDQ VTOP 4k
R_T2 VTOP NEN 4k
M_EN NEN EN VSSQ VSSQ NCH W=1u L=0.04u M=1
X_CI3 CODE[3] CB3 VDD VSS INV_D1
M_H3 VTOP CODE[3] SW3 VSSQ NCH W=1u L=0.04u M=1
M_L3 SW3 CB3 VSSQ VSSQ NCH W=1u L=0.04u M=1
X_CI2 CODE[2] CB2 VDD VSS INV_D1
M_H2 VTOP CODE[2] SW2 VSSQ NCH W=1u L=0.04u M=1
M_L2 SW2 CB2 VSSQ VSSQ NCH W=1u L=0.04u M=1
X_CI1 CODE[1] CB1 VDD VSS INV_D1
M_H1 VTOP CODE[1] SW1 VSSQ NCH W=1u L=0.04u M=1
M_L1 SW1 CB1 VSSQ VSSQ NCH W=1u L=0.04u M=1
X_CI0 CODE[0] CB0 VDD VSS INV_D1
M_H0 VTOP CODE[0] SW0 VSSQ NCH W=1u L=0.04u M=1
M_L0 SW0 CB0 VSSQ VSSQ NCH W=1u L=0.04u M=1
R_2R0 SW0 LN0 2k
R_2R1 SW1 LN1 2k
R_2R2 SW2 LN2 2k
R_2R3 SW3 VREF 2k
R_TRM LN0 VSSQ 2k
R_R0 LN0 LN1 1k
R_R1 LN1 LN2 1k
R_R2 LN2 VREF 1k
C_VR VREF VSSQ 2p
.ENDS VREF_R2R
** End of subcircuit definition.

** Library name: LP5IO_REF
** Cell name: BIAS_GEN
** View name: schematic
.SUBCKT BIAS_GEN IBIAS EN VBN VBP_A VBP_B VDD VSS
M_D1 IBIAS IBIAS VSS VSS NCH W=2u L=0.5u M=1
M_M1 VBP_B IBIAS VSS VSS NCH W=2u L=0.5u M=1
M_D2 VBP_B VBP_B VDD VDD PCH W=4u L=0.5u M=1
M_M2 VBN VBP_B VDD VDD PCH W=4u L=0.5u M=1
M_D3 VBN VBN VSS VSS NCH W=2u L=0.5u M=1
M_M3 VBP_A IBIAS NS3 VSS NCH W=2u L=0.5u M=1
M_ENN NS3 EN VSS VSS NCH W=2u L=0.04u M=1
M_D4 VBP_A VBP_A VDD VDD PCH W=4u L=0.5u M=1
M_OFF VBP_A EN VDD VDD PCH W=1u L=0.04u M=1
.ENDS BIAS_GEN
** End of subcircuit definition.

** Library name: LP5IO_CLK
** Cell name: CML_BUF
** View name: schematic
.SUBCKT CML_BUF INP INN ENB VBP OUTP OUTN VDD VSS
M_E TE ENB VDD VDD PCH W=4u L=0.04u M=1
M_T TS VBP TE VDD PCH W=4u L=0.1u M=1
M_1 OUTN INP TS VDD PCH_LVT W=3u L=0.04u M=1
M_2 OUTP INN TS VDD PCH_LVT W=3u L=0.04u M=1
R_1 OUTN VSS 600
R_2 OUTP VSS 600
.ENDS CML_BUF
** End of subcircuit definition.

** Library name: LP5IO_CLK
** Cell name: CML2CMOS
** View name: schematic
.SUBCKT CML2CMOS INP INN VBN OUT VDD VSS
M_T TS VBN VSS VSS NCH W=1u L=0.1u M=1
M_1 XD INP TS VSS NCH_LVT W=1u L=0.04u M=1
M_2 YO INN TS VSS NCH_LVT W=1u L=0.04u M=1
M_3 XD XD VDD VDD PCH_LVT W=1u L=0.04u M=1
M_4 YO XD VDD VDD PCH_LVT W=1u L=0.04u M=1
X_I1 YO YB VDD VSS INV_D1
X_I2 YB OUT VDD VSS INV_D4
.ENDS CML2CMOS
** End of subcircuit definition.

** Library name: LP5IO_CLK
** Cell name: DCA_CS
** View name: schematic
.SUBCKT DCA_CS IN VCTRL OUT VDD VSS
M_P1 A IN VDD VDD PCH_LVT W=1.6u L=0.04u M=1
M_N1 A IN SN VSS NCH_LVT W=0.8u L=0.04u M=1
M_NS SN VCTRL VSS VSS NCH W=0.8u L=0.08u M=1
M_NM SN VDD VSS VSS NCH W=0.2u L=0.08u M=1
M_P2 OUT A VDD VDD PCH_LVT W=1.6u L=0.04u M=1
M_N2 OUT A VSS VSS NCH_LVT W=0.8u L=0.04u M=1
.ENDS DCA_CS
** End of subcircuit definition.

** Library name: LP5IO_CLK
** Cell name: DLAT_D
** View name: schematic
.SUBCKT DLAT_D D DB CK CKB RST RSTB Q QB VDD VSS
M_A1 NA1 D VDD VDD PCH_LVT W=0.6u L=0.04u M=1
M_A2 QB CKB NA1 VDD PCH_LVT W=0.6u L=0.04u M=1
M_A3 QB CK NA2 VSS NCH_LVT W=0.4u L=0.04u M=1
M_A4 NA2 D VSS VSS NCH_LVT W=0.4u L=0.04u M=1
M_B1 NB1 DB VDD VDD PCH_LVT W=0.6u L=0.04u M=1
M_B2 Q CKB NB1 VDD PCH_LVT W=0.6u L=0.04u M=1
M_B3 Q CK NB2 VSS NCH_LVT W=0.4u L=0.04u M=1
M_B4 NB2 DB VSS VSS NCH_LVT W=0.4u L=0.04u M=1
M_K1 QB Q VDD VDD PCH W=0.15u L=0.12u M=1
M_K2 QB Q VSS VSS NCH W=0.15u L=0.12u M=1
M_K3 Q QB VDD VDD PCH W=0.15u L=0.12u M=1
M_K4 Q QB VSS VSS NCH W=0.15u L=0.12u M=1
M_RN Q RST VSS VSS NCH W=0.6u L=0.04u M=1
M_RP QB RSTB VDD VDD PCH W=1.2u L=0.04u M=1
.ENDS DLAT_D
** End of subcircuit definition.

** Library name: LP5IO_CLK
** Cell name: DIV2_IQ
** View name: schematic
.SUBCKT DIV2_IQ CK RST PH[3] PH[2] PH[1] PH[0] VDD VSS
M_CIN CKB CK VSS VSS NCH_LVT W=0.8u L=0.04u M=1
M_CIP CKB CK VDD VDD PCH_LVT W=1.6u L=0.04u M=1
M_RIN RSTB RST VSS VSS NCH W=0.2u L=0.04u M=1
M_RIP RSTB RST VDD VDD PCH W=0.4u L=0.04u M=1
X_L1 PH[3] PH[1] CK CKB RST RSTB PH[0] PH[2] VDD VSS DLAT_D
X_L2 PH[0] PH[2] CKB CK RST RSTB PH[1] PH[3] VDD VSS DLAT_D
.ENDS DIV2_IQ
** End of subcircuit definition.

** Library name: LP5IO_CLK
** Cell name: DCC_DET
** View name: schematic
.SUBCKT DCC_DET CK VP VN VDD VSS
M_1N N1 CK VSS VSS NCH W=0.4u L=0.04u M=1
M_1P N1 CK VDD VDD PCH W=0.8u L=0.04u M=1
M_2N TR N1 VSS VSS NCH W=0.4u L=0.04u M=1
M_2P TR N1 VDD VDD PCH W=0.8u L=0.04u M=1
M_GN CP VDD N1 VSS NCH W=0.4u L=0.04u M=1
M_GP CP VSS N1 VDD PCH W=0.8u L=0.04u M=1
R_T TR VP 100k
C_P VP VSS 1p
R_C CP VN 100k
C_N VN VSS 1p
C_D VP VN 0.5p
.ENDS DCC_DET
** End of subcircuit definition.

** Library name: LP5IO_CLK
** Cell name: DCC_OTA
** View name: schematic
.SUBCKT DCC_OTA INP INN EN VBN OUT VDD VSS
M_E TE EN VSS VSS NCH W=1u L=0.04u M=1
M_T TS VBN TE VSS NCH W=1u L=0.2u M=1
M_1 XD INP TS VSS NCH W=1u L=0.1u M=1
M_2 OUT INN TS VSS NCH W=1u L=0.1u M=1
M_3 XD XD VDD VDD PCH W=1u L=0.2u M=1
M_4 OUT XD VDD VDD PCH W=1u L=0.2u M=1
.ENDS DCC_OTA
** End of subcircuit definition.

** Library name: LP5IO_CLK
** Cell name: DCC_LOOP
** View name: schematic
.SUBCKT DCC_LOOP CK EN RST VBN VCTRL VDD VSS
X_DET CK VP VN VDD VSS DCC_DET
X_OTA VN VP EN VBN VCTRL VDD VSS DCC_OTA
C_INT VCTRL VSS 2p
X_ENI EN ENB VDD VSS INV_D1
X_RNR RST ENB RSTXB VDD VSS NOR2_D1
X_RSI RSTXB RSTX VDD VSS INV_D1
M_SWN VCTRL RSTX VPRE VSS NCH W=0.4u L=0.04u M=1
M_SWP VCTRL RSTXB VPRE VDD PCH W=0.4u L=0.04u M=1
R_P1 VDD VPRE 20k
R_P2 VPRE VSS 30k
.ENDS DCC_LOOP
** End of subcircuit definition.

** Library name: LP5IO_CLK
** Cell name: CLK_GEN
** View name: schematic
.SUBCKT CLK_GEN WCKI WCKBI CK_EN DCC_EN DCC_RST DIV_RST VBP VBN PH[3] PH[2] PH[1] PH[0]
+ VDD VSS
X_ENI CK_EN CKENB VDD VSS INV_D1
X_CML WCKI WCKBI CKENB VBP CMLP CMLN VDD VSS CML_BUF
X_C2C CMLP CMLN VBN CKC VDD VSS CML2CMOS
X_DCA CKC VCTRL CKA VDD VSS DCA_CS
X_DCC CKA DCC_EN DCC_RST VBN VCTRL VDD VSS DCC_LOOP
X_DIV CKA DIV_RST PH[3] PH[2] PH[1] PH[0] VDD VSS DIV2_IQ
.ENDS CLK_GEN
** End of subcircuit definition.

** Library name: LP5IO_CLK
** Cell name: CLK_TREE
** View name: schematic
.SUBCKT CLK_TREE PH[3] PH[2] PH[1] PH[0] PHL[3] PHL[2] PHL[1] PHL[0] PHR[3] PHR[2]
+ PHR[1] PHR[0] VDD VSS
X_RA0 PH[0] RA0 VDD VSS INV_D4
X_RB0 RA0 RB0 VDD VSS INV_D4
X_SL0 RB0 SLD0 VDD VSS INV_D4
R_WL0 SLD0 PHL[2] 30
C_WL0 PHL[2] VSS 20f
X_SR0 RB0 SRD0 VDD VSS INV_D4
R_WR0 SRD0 PHR[2] 30
C_WR0 PHR[2] VSS 20f
X_RA1 PH[1] RA1 VDD VSS INV_D4
X_RB1 RA1 RB1 VDD VSS INV_D4
X_SL1 RB1 SLD1 VDD VSS INV_D4
R_WL1 SLD1 PHL[3] 30
C_WL1 PHL[3] VSS 20f
X_SR1 RB1 SRD1 VDD VSS INV_D4
R_WR1 SRD1 PHR[3] 30
C_WR1 PHR[3] VSS 20f
X_RA2 PH[2] RA2 VDD VSS INV_D4
X_RB2 RA2 RB2 VDD VSS INV_D4
X_SL2 RB2 SLD2 VDD VSS INV_D4
R_WL2 SLD2 PHL[0] 30
C_WL2 PHL[0] VSS 20f
X_SR2 RB2 SRD2 VDD VSS INV_D4
R_WR2 SRD2 PHR[0] 30
C_WR2 PHR[0] VSS 20f
X_RA3 PH[3] RA3 VDD VSS INV_D4
X_RB3 RA3 RB3 VDD VSS INV_D4
X_SL3 RB3 SLD3 VDD VSS INV_D4
R_WL3 SLD3 PHL[1] 30
C_WL3 PHL[1] VSS 20f
X_SR3 RB3 SRD3 VDD VSS INV_D4
R_WR3 SRD3 PHR[1] 30
C_WR3 PHR[1] VSS 20f
.ENDS CLK_TREE
** End of subcircuit definition.

** Library name: LP5IO_CAL
** Cell name: CAL_CTRL
** View name: schematic
.SUBCKT CAL_CTRL CAL_EN CKIN CAL_CK CAL_RUN CAL_ENB CAL_DONE VDD VSS
X_DV0 DV0B CKIN DV0 DV0B VDD VSS DFF_TSPC
X_DV1 DV1B DV0 CAL_CK DV1B VDD VSS DFF_TSPC
X_DV2 DV2B CAL_CK DV2 DV2B VDD VSS DFF_TSPC
X_S0 CAL_EN DV2 S0 S0B VDD VSS DFF_TSPC
X_S1 S0 DV2 S1 S1B VDD VSS DFF_TSPC
X_S2 S1 DV2 S2 S2B VDD VSS DFF_TSPC
X_S3 S2 DV2 S3 S3B VDD VSS DFF_TSPC
X_S4 S3 DV2 S4 S4B VDD VSS DFF_TSPC
X_DN S4 CAL_EN DONEB VDD VSS NAND2_D1
X_DI DONEB CAL_DONE VDD VSS INV_D1
X_RN CAL_EN DONEB RUNB VDD VSS NAND2_D1
X_RI RUNB CAL_RUN VDD VSS INV_D1
X_EI CAL_EN CAL_ENB VDD VSS INV_D1
.ENDS CAL_CTRL
** End of subcircuit definition.

** Library name: LP5IO_CAL
** Cell name: ZQ_CMP
** View name: schematic
.SUBCKT ZQ_CMP INP INN EN VBP OUTB VDD VSS
M_EIN ENB EN VSS VSS NCH W=0.2u L=0.04u M=1
M_EIP ENB EN VDD VDD PCH W=0.4u L=0.04u M=1
M_E TE ENB VDD VDD PCH W=2u L=0.04u M=1
M_T TS VBP TE VDD PCH W=2u L=0.2u M=1
M_1 XD INP TS VDD PCH W=2u L=0.2u M=1
M_2 YO INN TS VDD PCH W=2u L=0.2u M=1
M_3 XD XD VSS VSS NCH W=1u L=0.2u M=1
M_4 YO XD VSS VSS NCH W=1u L=0.2u M=1
M_5 OUTB YO VSS VSS NCH W=1u L=0.1u M=1
M_6 OUTB VBP VDD VDD PCH W=1u L=0.2u M=1
.ENDS ZQ_CMP
** End of subcircuit definition.

** Library name: LP5IO_CAL
** Cell name: ZQ_SAR5
** View name: schematic
.SUBCKT ZQ_SAR5 START CLK KEEPB CODE[4] CODE[3] CODE[2] CODE[1] CODE[0] DONE BUSY VDD
+ VSS
X_T4 START CLK T4 T4B VDD VSS DFF_TSPC
X_NT3 T4B START TD3 VDD VSS NOR2_D1
X_T3 TD3 CLK T3 T3B VDD VSS DFF_TSPC
X_NT2 T3B START TD2 VDD VSS NOR2_D1
X_T2 TD2 CLK T2 T2B VDD VSS DFF_TSPC
X_NT1 T2B START TD1 VDD VSS NOR2_D1
X_T1 TD1 CLK T1 T1B VDD VSS DFF_TSPC
X_NT0 T1B START TD0 VDD VSS NOR2_D1
X_T0 TD0 CLK T0 T0B VDD VSS DFF_TSPC
X_M4 CB4 KEEPB T4 T4B MX4 VDD VSS TGMUX2
X_NC4 MX4 START CD4 VDD VSS NOR2_D1
X_C4 CD4 CLK C4 CB4 VDD VSS DFF_TSPC
X_O4 CB4 T4B CODE[4] VDD VSS NAND2_D1
X_M3 CB3 KEEPB T3 T3B MX3 VDD VSS TGMUX2
X_NC3 MX3 START CD3 VDD VSS NOR2_D1
X_C3 CD3 CLK C3 CB3 VDD VSS DFF_TSPC
X_O3 CB3 T3B CODE[3] VDD VSS NAND2_D1
X_M2 CB2 KEEPB T2 T2B MX2 VDD VSS TGMUX2
X_NC2 MX2 START CD2 VDD VSS NOR2_D1
X_C2 CD2 CLK C2 CB2 VDD VSS DFF_TSPC
X_O2 CB2 T2B CODE[2] VDD VSS NAND2_D1
X_M1 CB1 KEEPB T1 T1B MX1 VDD VSS TGMUX2
X_NC1 MX1 START CD1 VDD VSS NOR2_D1
X_C1 CD1 CLK C1 CB1 VDD VSS DFF_TSPC
X_O1 CB1 T1B CODE[1] VDD VSS NAND2_D1
X_M0 CB0 KEEPB T0 T0B MX0 VDD VSS TGMUX2
X_NC0 MX0 START CD0 VDD VSS NOR2_D1
X_C0 CD0 CLK C0 CB0 VDD VSS DFF_TSPC
X_O0 CB0 T0B CODE[0] VDD VSS NAND2_D1
X_ND1 T0 DONE DN1 VDD VSS NOR2_D1
X_ND2 DN1 START DD VDD VSS NOR2_D1
X_FD DD CLK DONE DONEB VDD VSS DFF_TSPC
X_BI DONE BUSY VDD VSS INV_D1
.ENDS ZQ_SAR5
** End of subcircuit definition.

** Library name: LP5IO_CAL
** Cell name: ZQ_RLEG
** View name: schematic
.SUBCKT ZQ_RLEG ON EN PAD VSSQ
R_Z PAD NZ1 1.8k
M_ON NZ1 ON NZ2 VSSQ NCH W=0.4u L=0.04u M=1
M_EN NZ2 EN VSSQ VSSQ NCH W=0.4u L=0.04u M=1
.ENDS ZQ_RLEG
** End of subcircuit definition.

** Library name: LP5IO_CAL
** Cell name: ZQ_CAL
** View name: schematic
.SUBCKT ZQ_CAL ZQ ZCLK ZSTART VBP ZCODE[4] ZCODE[3] ZCODE[2] ZCODE[1] ZCODE[0] ZDONE VDD
+ VSS VDDQ VSSQ
R_D1 VDDQ ZREF 10k
R_D2 ZREF ND 10k
M_DEN ND BUSY VSSQ VSSQ NCH W=1u L=0.04u M=1
C_ZR ZREF VSSQ 1p
X_CMP ZQ ZREF BUSY VBP KEEPB VDD VSS ZQ_CMP
X_SAR ZSTART ZCLK KEEPB ZCODE[4] ZCODE[3] ZCODE[2] ZCODE[1] ZCODE[0] ZDONE BUSY VDD VSS
+ ZQ_SAR5
X_RL4 BUSY ZCODE[4] ZQ VSSQ ZQ_RLEG M=16
X_RL3 BUSY ZCODE[3] ZQ VSSQ ZQ_RLEG M=8
X_RL2 BUSY ZCODE[2] ZQ VSSQ ZQ_RLEG M=4
X_RL1 BUSY ZCODE[1] ZQ VSSQ ZQ_RLEG M=2
X_RL0 BUSY ZCODE[0] ZQ VSSQ ZQ_RLEG M=1
.ENDS ZQ_CAL
** End of subcircuit definition.

** Library name: LP5IO_ESD
** Cell name: ESD_DIO2
** View name: schematic
.SUBCKT ESD_DIO2 PAD VDDQ VSSQ
M_DP PAD VDDQ VDDQ VDDQ PCH_IO W=20u L=0.15u M=4
M_DN PAD VSSQ VSSQ VSSQ NCH_IO W=20u L=0.15u M=4
.ENDS ESD_DIO2
** End of subcircuit definition.

** Library name: LP5IO_ESD
** Cell name: ESD_CLAMP
** View name: schematic
.SUBCKT ESD_CLAMP VP VN
R_RC VP RC 200k
C_RC RC VN 2p
M_IP TRG RC VP VP PCH_IO W=20u L=0.15u M=1
M_IN TRG RC VN VN NCH_IO W=10u L=0.15u M=1
M_BIG VP TRG VN VN NCH_IO W=50u L=0.15u M=40
.ENDS ESD_CLAMP
** End of subcircuit definition.

** Library name: LP5IO_ESD
** Cell name: PAD_IN
** View name: schematic
.SUBCKT PAD_IN PAD PADR VDDQ VSSQ
X_ESD PAD VDDQ VSSQ ESD_DIO2
R_SEC PAD PADR 100
.ENDS PAD_IN
** End of subcircuit definition.

** Library name: LP5IO_TOP
** Cell name: DQ_SLICE
** View name: schematic
.SUBCKT DQ_SLICE PAD TXD[3] TXD[2] TXD[1] TXD[0] RXD[3] RXD[2] RXD[1] RXD[0] PH[3] PH[2]
+ PH[1] PH[0] SR[1] SR[0] SRB[1] SRB[0] EN_M[4] EN_M[3] EN_M[2] EN_M[1] EN_M[0] EN_P[2]
+ EN_P[1] EN_P[0] ODT_G[2] ODT_G[1] ODT_G[0] VREF CAL_EN CAL_ENB CAL_CK CAL_RUN
+ CTLE_C[1] CTLE_C[0] VBP VALF VDD VSS VDDQ VSSQ
X_ESD PAD VDDQ VSSQ ESD_DIO2
R_SEC PAD PADR 150
C_PAD PAD VSSQ 0.3p
X_ODT ODT_G[2] ODT_G[1] ODT_G[0] PAD VSSQ ODT_PD
X_TX TXD[3] TXD[2] TXD[1] TXD[0] PH[3] PH[2] PH[1] PH[0] SR[1] SR[0] SRB[1] SRB[0]
+ EN_M[4] EN_M[3] EN_M[2] EN_M[1] EN_M[0] EN_P[2] EN_P[1] EN_P[0] PAD VDD VSS VDDQ VSSQ
+ TX_DQ
X_RX PADR VREF CAL_EN CAL_ENB PH[3] PH[2] PH[1] PH[0] CTLE_C[1] CTLE_C[0] VBP VALF
+ CAL_CK CAL_RUN RXD[3] RXD[2] RXD[1] RXD[0] VDD VSS RX_DQ
.ENDS DQ_SLICE
** End of subcircuit definition.

** Library name: LP5IO_TOP
** Cell name: LP5_DQ_BYTE
** View name: schematic
.SUBCKT LP5_DQ_BYTE DQ[7] DQ[6] DQ[5] DQ[4] DQ[3] DQ[2] DQ[1] DQ[0] WCK WCKB ZQ TXD[31]
+ TXD[30] TXD[29] TXD[28] TXD[27] TXD[26] TXD[25] TXD[24] TXD[23] TXD[22] TXD[21]
+ TXD[20] TXD[19] TXD[18] TXD[17] TXD[16] TXD[15] TXD[14] TXD[13] TXD[12] TXD[11]
+ TXD[10] TXD[9] TXD[8] TXD[7] TXD[6] TXD[5] TXD[4] TXD[3] TXD[2] TXD[1] TXD[0] RXD[31]
+ RXD[30] RXD[29] RXD[28] RXD[27] RXD[26] RXD[25] RXD[24] RXD[23] RXD[22] RXD[21]
+ RXD[20] RXD[19] RXD[18] RXD[17] RXD[16] RXD[15] RXD[14] RXD[13] RXD[12] RXD[11]
+ RXD[10] RXD[9] RXD[8] RXD[7] RXD[6] RXD[5] RXD[4] RXD[3] RXD[2] RXD[1] RXD[0] TXCLK
+ RXCLK OE EQ_EN SR[1] SR[0] ODT_EN ODT_CODE[2] ODT_CODE[1] ODT_CODE[0] VREF_CODE[3]
+ VREF_CODE[2] VREF_CODE[1] VREF_CODE[0] CTLE_CODE[1] CTLE_CODE[0] DFE_TAP[2] DFE_TAP[1]
+ DFE_TAP[0] RX_EN CAL_EN CAL_DONE ZQ_CLK ZQ_START ZQ_DONE ZQ_CODE[4] ZQ_CODE[3]
+ ZQ_CODE[2] ZQ_CODE[1] ZQ_CODE[0] CK_EN DIV_RST DCC_EN DCC_RST IBIAS VDD VSS VDDQ VSSQ
X_PAD_WCK WCK WCKI VDDQ VSSQ PAD_IN
X_PAD_WCKB WCKB WCKBI VDDQ VSSQ PAD_IN
X_ESD_ZQ ZQ VDDQ VSSQ ESD_DIO2
X_CLAMP_Q VDDQ VSSQ ESD_CLAMP
X_CLAMP_C VDD VSS ESD_CLAMP
X_BIAS IBIAS RX_EN VBN VBP_RX VBP_AO VDD VSS BIAS_GEN
X_CKGEN WCKI WCKBI CK_EN DCC_EN DCC_RST DIV_RST VBP_AO VBN PH[3] PH[2] PH[1] PH[0] VDD
+ VSS CLK_GEN
X_CKTREE PH[3] PH[2] PH[1] PH[0] PHL[3] PHL[2] PHL[1] PHL[0] PHR[3] PHR[2] PHR[1] PHR[0]
+ VDD VSS CLK_TREE
X_TCB0 PHL[2] TCK1 VDD VSS INV_D4
X_TCB1 TCK1 TXCLK VDD VSS INV_D4
X_RCB0 PHL[0] RCK1 VDD VSS INV_D4
X_RCB1 RCK1 RXCLK VDD VSS INV_D4
X_VREF VREF_CODE[3] VREF_CODE[2] VREF_CODE[1] VREF_CODE[0] RX_EN VREF VDD VSS VDDQ VSSQ
+ VREF_R2R
X_TAP DFE_TAP[2] DFE_TAP[1] DFE_TAP[0] CAL_ENB VBP_RX VALF VDD VSS TAP_DAC
X_CAL CAL_EN PHL[2] CAL_CK CAL_RUN CAL_ENB CAL_DONE VDD VSS CAL_CTRL
X_ZQ ZQ ZQ_CLK ZQ_START VBP_AO ZQ_CODE[4] ZQ_CODE[3] ZQ_CODE[2] ZQ_CODE[1] ZQ_CODE[0]
+ ZQ_DONE VDD VSS VDDQ VSSQ ZQ_CAL
X_TXCTL ZQ_CODE[4] ZQ_CODE[3] ZQ_CODE[2] ZQ_CODE[1] ZQ_CODE[0] OE EQ_EN SR[1] SR[0]
+ EN_M[4] EN_M[3] EN_M[2] EN_M[1] EN_M[0] EN_P[2] EN_P[1] EN_P[0] SRB[1] SRB[0] VDD VSS
+ TX_CTRL
X_ODTCTL ODT_EN ODT_CODE[2] ODT_CODE[1] ODT_CODE[0] OE ODT_G[2] ODT_G[1] ODT_G[0] VDD
+ VSS ODT_CTRL
X_DQ0 DQ[0] TXD[3] TXD[2] TXD[1] TXD[0] RXD[3] RXD[2] RXD[1] RXD[0] PHL[3] PHL[2] PHL[1]
+ PHL[0] SR[1] SR[0] SRB[1] SRB[0] EN_M[4] EN_M[3] EN_M[2] EN_M[1] EN_M[0] EN_P[2]
+ EN_P[1] EN_P[0] ODT_G[2] ODT_G[1] ODT_G[0] VREF CAL_EN CAL_ENB CAL_CK CAL_RUN
+ CTLE_CODE[1] CTLE_CODE[0] VBP_RX VALF VDD VSS VDDQ VSSQ DQ_SLICE
X_DQ1 DQ[1] TXD[7] TXD[6] TXD[5] TXD[4] RXD[7] RXD[6] RXD[5] RXD[4] PHL[3] PHL[2] PHL[1]
+ PHL[0] SR[1] SR[0] SRB[1] SRB[0] EN_M[4] EN_M[3] EN_M[2] EN_M[1] EN_M[0] EN_P[2]
+ EN_P[1] EN_P[0] ODT_G[2] ODT_G[1] ODT_G[0] VREF CAL_EN CAL_ENB CAL_CK CAL_RUN
+ CTLE_CODE[1] CTLE_CODE[0] VBP_RX VALF VDD VSS VDDQ VSSQ DQ_SLICE
X_DQ2 DQ[2] TXD[11] TXD[10] TXD[9] TXD[8] RXD[11] RXD[10] RXD[9] RXD[8] PHL[3] PHL[2]
+ PHL[1] PHL[0] SR[1] SR[0] SRB[1] SRB[0] EN_M[4] EN_M[3] EN_M[2] EN_M[1] EN_M[0]
+ EN_P[2] EN_P[1] EN_P[0] ODT_G[2] ODT_G[1] ODT_G[0] VREF CAL_EN CAL_ENB CAL_CK CAL_RUN
+ CTLE_CODE[1] CTLE_CODE[0] VBP_RX VALF VDD VSS VDDQ VSSQ DQ_SLICE
X_DQ3 DQ[3] TXD[15] TXD[14] TXD[13] TXD[12] RXD[15] RXD[14] RXD[13] RXD[12] PHL[3]
+ PHL[2] PHL[1] PHL[0] SR[1] SR[0] SRB[1] SRB[0] EN_M[4] EN_M[3] EN_M[2] EN_M[1] EN_M[0]
+ EN_P[2] EN_P[1] EN_P[0] ODT_G[2] ODT_G[1] ODT_G[0] VREF CAL_EN CAL_ENB CAL_CK CAL_RUN
+ CTLE_CODE[1] CTLE_CODE[0] VBP_RX VALF VDD VSS VDDQ VSSQ DQ_SLICE
X_DQ4 DQ[4] TXD[19] TXD[18] TXD[17] TXD[16] RXD[19] RXD[18] RXD[17] RXD[16] PHR[3]
+ PHR[2] PHR[1] PHR[0] SR[1] SR[0] SRB[1] SRB[0] EN_M[4] EN_M[3] EN_M[2] EN_M[1] EN_M[0]
+ EN_P[2] EN_P[1] EN_P[0] ODT_G[2] ODT_G[1] ODT_G[0] VREF CAL_EN CAL_ENB CAL_CK CAL_RUN
+ CTLE_CODE[1] CTLE_CODE[0] VBP_RX VALF VDD VSS VDDQ VSSQ DQ_SLICE
X_DQ5 DQ[5] TXD[23] TXD[22] TXD[21] TXD[20] RXD[23] RXD[22] RXD[21] RXD[20] PHR[3]
+ PHR[2] PHR[1] PHR[0] SR[1] SR[0] SRB[1] SRB[0] EN_M[4] EN_M[3] EN_M[2] EN_M[1] EN_M[0]
+ EN_P[2] EN_P[1] EN_P[0] ODT_G[2] ODT_G[1] ODT_G[0] VREF CAL_EN CAL_ENB CAL_CK CAL_RUN
+ CTLE_CODE[1] CTLE_CODE[0] VBP_RX VALF VDD VSS VDDQ VSSQ DQ_SLICE
X_DQ6 DQ[6] TXD[27] TXD[26] TXD[25] TXD[24] RXD[27] RXD[26] RXD[25] RXD[24] PHR[3]
+ PHR[2] PHR[1] PHR[0] SR[1] SR[0] SRB[1] SRB[0] EN_M[4] EN_M[3] EN_M[2] EN_M[1] EN_M[0]
+ EN_P[2] EN_P[1] EN_P[0] ODT_G[2] ODT_G[1] ODT_G[0] VREF CAL_EN CAL_ENB CAL_CK CAL_RUN
+ CTLE_CODE[1] CTLE_CODE[0] VBP_RX VALF VDD VSS VDDQ VSSQ DQ_SLICE
X_DQ7 DQ[7] TXD[31] TXD[30] TXD[29] TXD[28] RXD[31] RXD[30] RXD[29] RXD[28] PHR[3]
+ PHR[2] PHR[1] PHR[0] SR[1] SR[0] SRB[1] SRB[0] EN_M[4] EN_M[3] EN_M[2] EN_M[1] EN_M[0]
+ EN_P[2] EN_P[1] EN_P[0] ODT_G[2] ODT_G[1] ODT_G[0] VREF CAL_EN CAL_ENB CAL_CK CAL_RUN
+ CTLE_CODE[1] CTLE_CODE[0] VBP_RX VALF VDD VSS VDDQ VSSQ DQ_SLICE
M_DCAP VSS VDD VSS VSS NCH W=10u L=1u M=20
C_DCQ VDDQ VSSQ 20p
.ENDS LP5_DQ_BYTE
** End of subcircuit definition.

.END
