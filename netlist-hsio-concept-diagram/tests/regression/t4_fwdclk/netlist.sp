* HSPICE netlist
* Generated by: Custom Compiler netlister (hspice), version W-2024.09-SP2
* Top cell: FCL_TOP/fcl_link_top/schematic
* Netlisted on: Nov 15 2026 10:14:07
* Netlist options: hierarchical, globals=on, param_inherit=on

.option scale=1.0 post=2 ingold=2
.temp 25

.global vddd vssd

.param lmin=40n lmed=80n lkp=120n lcs=200n lhv=270n
.param wn1=200n wp1=400n wtn=200n wtp=300n wkn=150n wkp=150n
.param wcml=2u wtail=1u wsw=1u wesd=10u whv=1u whvp=2u whvesd=20u

.model nch     nmos level=54 version=4.7 vth0=0.38  toxe=1.8n
.model pch     pmos level=54 version=4.7 vth0=-0.38 toxe=1.8n
.model nch_lvt nmos level=54 version=4.7 vth0=0.26  toxe=1.8n
.model nch_hv  nmos level=54 version=4.7 vth0=0.52  toxe=5.0n
.model pch_hv  pmos level=54 version=4.7 vth0=-0.52 toxe=5.0n

*----------------------------------------------------------------------
* Library: FCL_STD   Cell: fcd_inv   View: schematic
*----------------------------------------------------------------------
.subckt fcd_inv a y
MN0 y a vssd vssd nch W=wn1 L=lmin m=1 nf=1
MP0 y a vddd vddd pch W=wp1 L=lmin m=1 nf=1
.ends fcd_inv

*----------------------------------------------------------------------
* Library: FCL_STD   Cell: fcd_inv4   View: schematic
*----------------------------------------------------------------------
.subckt fcd_inv4 a y
MN0 y a vssd vssd nch W=wn1 L=lmin m=4 nf=1
MP0 y a vddd vddd pch W=wp1 L=lmin m=4 nf=1
.ends fcd_inv4

*----------------------------------------------------------------------
* Library: FCL_STD   Cell: fcd_nand2   View: schematic
*----------------------------------------------------------------------
.subckt fcd_nand2 a b y
MN0 y a n0 vssd nch W='2*wn1' L=lmin m=1 nf=1
MN1 n0 b vssd vssd nch W='2*wn1' L=lmin m=1 nf=1
MP0 y a vddd vddd pch W=wp1 L=lmin m=1 nf=1
MP1 y b vddd vddd pch W=wp1 L=lmin m=1 nf=1
.ends fcd_nand2

*----------------------------------------------------------------------
* Library: FCL_STD   Cell: fcd_nor2   View: schematic
*----------------------------------------------------------------------
.subckt fcd_nor2 a b y
MN0 y a vssd vssd nch W=wn1 L=lmin m=1 nf=1
MN1 y b vssd vssd nch W=wn1 L=lmin m=1 nf=1
MP0 n0 a vddd vddd pch W='2*wp1' L=lmin m=1 nf=1
MP1 y b n0 vddd pch W='2*wp1' L=lmin m=1 nf=1
.ends fcd_nor2

*----------------------------------------------------------------------
* Library: FCL_STD   Cell: fcd_xor2   View: schematic
*----------------------------------------------------------------------
.subckt fcd_xor2 a b y
MN0 an a vssd vssd nch W=wn1 L=lmin m=1 nf=1
MP0 an a vddd vddd pch W=wp1 L=lmin m=1 nf=1
MN1 bn b vssd vssd nch W=wn1 L=lmin m=1 nf=1
MP1 bn b vddd vddd pch W=wp1 L=lmin m=1 nf=1
MN2 y bn a vssd nch W=wtn L=lmin m=1 nf=1
MP2 y b a vddd pch W=wtp L=lmin m=1 nf=1
MN3 y b an vssd nch W=wtn L=lmin m=1 nf=1
MP3 y bn an vddd pch W=wtp L=lmin m=1 nf=1
.ends fcd_xor2

*----------------------------------------------------------------------
* Library: FCL_STD   Cell: fcd_majb3   View: schematic
*----------------------------------------------------------------------
.subckt fcd_majb3 a b c y
MN0 y a n1 vssd nch W='2*wn1' L=lmin m=1 nf=1
MN1 n1 b vssd vssd nch W='2*wn1' L=lmin m=1 nf=1
MN2 y c n2 vssd nch W='2*wn1' L=lmin m=1 nf=1
MN3 n2 a vssd vssd nch W='2*wn1' L=lmin m=1 nf=1
MN4 n2 b vssd vssd nch W='2*wn1' L=lmin m=1 nf=1
MP0 y a p1 vddd pch W='2*wp1' L=lmin m=1 nf=1
MP1 p1 b vddd vddd pch W='2*wp1' L=lmin m=1 nf=1
MP2 y c p2 vddd pch W='2*wp1' L=lmin m=1 nf=1
MP3 p2 a vddd vddd pch W='2*wp1' L=lmin m=1 nf=1
MP4 p2 b vddd vddd pch W='2*wp1' L=lmin m=1 nf=1
.ends fcd_majb3

*----------------------------------------------------------------------
* Library: FCL_STD   Cell: fcd_tgmux   View: schematic
*----------------------------------------------------------------------
.subckt fcd_tgmux d0 d1 s sb y
MN0 y sb d0 vssd nch W=wtn L=lmin m=1 nf=1
MP0 y s d0 vddd pch W=wtp L=lmin m=1 nf=1
MN1 y s d1 vssd nch W=wtn L=lmin m=1 nf=1
MP1 y sb d1 vddd pch W=wtp L=lmin m=1 nf=1
.ends fcd_tgmux

*----------------------------------------------------------------------
* Library: FCL_STD   Cell: fcd_ckbuf   View: schematic
*----------------------------------------------------------------------
.subckt fcd_ckbuf a y yb
MN0 yb a vssd vssd nch W='2*wn1' L=lmin m=1 nf=1
MP0 yb a vddd vddd pch W='2*wp1' L=lmin m=1 nf=1
MN1 y yb vssd vssd nch W='4*wn1' L=lmin m=1 nf=1
MP1 y yb vddd vddd pch W='4*wp1' L=lmin m=1 nf=1
.ends fcd_ckbuf

*----------------------------------------------------------------------
* Library: FCL_STD   Cell: fcd_dff   View: schematic
*----------------------------------------------------------------------
.subckt fcd_dff d ck ckb q qb
MN0 m1 ckb d vssd nch W=wtn L=lmin m=1 nf=1
MP0 m1 ck d vddd pch W=wtp L=lmin m=1 nf=1
MN1 m2 m1 vssd vssd nch W=wn1 L=lmin m=1 nf=1
MP1 m2 m1 vddd vddd pch W=wp1 L=lmin m=1 nf=1
MN2 m3 m2 vssd vssd nch W=wkn L=lkp m=1 nf=1
MP2 m3 m2 vddd vddd pch W=wkp L=lkp m=1 nf=1
MN3 m1 ck m3 vssd nch W=wkn L=lkp m=1 nf=1
MP3 m1 ckb m3 vddd pch W=wkp L=lkp m=1 nf=1
MN4 s1 ck m2 vssd nch W=wtn L=lmin m=1 nf=1
MP4 s1 ckb m2 vddd pch W=wtp L=lmin m=1 nf=1
MN5 q s1 vssd vssd nch W=wn1 L=lmin m=1 nf=1
MP5 q s1 vddd vddd pch W=wp1 L=lmin m=1 nf=1
MN6 qb q vssd vssd nch W=wn1 L=lmin m=1 nf=1
MP6 qb q vddd vddd pch W=wp1 L=lmin m=1 nf=1
MN7 s1 ckb qb vssd nch W=wkn L=lkp m=1 nf=1
MP7 s1 ck qb vddd pch W=wkp L=lkp m=1 nf=1
.ends fcd_dff

*----------------------------------------------------------------------
* Library: FCL_STD   Cell: fcd_dffr   View: schematic
*----------------------------------------------------------------------
.subckt fcd_dffr d ck ckb rb q qb
MN0 m1 ckb d vssd nch W=wtn L=lmin m=1 nf=1
MP0 m1 ck d vddd pch W=wtp L=lmin m=1 nf=1
MN1 m2 m1 nx vssd nch W='2*wn1' L=lmin m=1 nf=1
MN8 nx rb vssd vssd nch W='2*wn1' L=lmin m=1 nf=1
MP1 m2 m1 vddd vddd pch W=wp1 L=lmin m=1 nf=1
MP8 m2 rb vddd vddd pch W=wp1 L=lmin m=1 nf=1
MN2 m3 m2 vssd vssd nch W=wkn L=lkp m=1 nf=1
MP2 m3 m2 vddd vddd pch W=wkp L=lkp m=1 nf=1
MN3 m1 ck m3 vssd nch W=wkn L=lkp m=1 nf=1
MP3 m1 ckb m3 vddd pch W=wkp L=lkp m=1 nf=1
MN4 s1 ck m2 vssd nch W=wtn L=lmin m=1 nf=1
MP4 s1 ckb m2 vddd pch W=wtp L=lmin m=1 nf=1
MN5 q s1 vssd vssd nch W=wn1 L=lmin m=1 nf=1
MP5 q s1 vddd vddd pch W=wp1 L=lmin m=1 nf=1
MN6 qb q ny vssd nch W='2*wn1' L=lmin m=1 nf=1
MN9 ny rb vssd vssd nch W='2*wn1' L=lmin m=1 nf=1
MP6 qb q vddd vddd pch W=wp1 L=lmin m=1 nf=1
MP9 qb rb vddd vddd pch W=wp1 L=lmin m=1 nf=1
MN7 s1 ckb qb vssd nch W=wkn L=lkp m=1 nf=1
MP7 s1 ck qb vddd pch W=wkp L=lkp m=1 nf=1
.ends fcd_dffr

*----------------------------------------------------------------------
* Library: FCL_STD   Cell: fcd_lat   View: schematic
*----------------------------------------------------------------------
.subckt fcd_lat d en enb q
MN0 l1 en d vssd nch W=wtn L=lmin m=1 nf=1
MP0 l1 enb d vddd pch W=wtp L=lmin m=1 nf=1
MN1 lb l1 vssd vssd nch W=wn1 L=lmin m=1 nf=1
MP1 lb l1 vddd vddd pch W=wp1 L=lmin m=1 nf=1
MN2 q lb vssd vssd nch W=wn1 L=lmin m=1 nf=1
MP2 q lb vddd vddd pch W=wp1 L=lmin m=1 nf=1
MN3 l1 enb q vssd nch W=wkn L=lkp m=1 nf=1
MP3 l1 en q vddd pch W=wkp L=lkp m=1 nf=1
.ends fcd_lat

*----------------------------------------------------------------------
* Library: FCL_ANA   Cell: fca_cmla   View: schematic
*----------------------------------------------------------------------
.subckt fca_cmla inp inn outp outn vbn avdd avss rl=600
R0 avdd outp 'rl'
R1 avdd outn 'rl'
MN0 outn inp tl avss nch_lvt W=wcml L=lmin m=2 nf=2
MN1 outp inn tl avss nch_lvt W=wcml L=lmin m=2 nf=2
MN2 tl vbn avss avss nch W=wtail L=lcs m=4 nf=1
.ends fca_cmla

*----------------------------------------------------------------------
* Library: FCL_ANA   Cell: fca_c2c   View: schematic
*----------------------------------------------------------------------
.subckt fca_c2c inp inn y vbn avdd avss
MN0 x1 inp tl avss nch_lvt W=wcml L=lmin m=1 nf=1
MN1 x2 inn tl avss nch_lvt W=wcml L=lmin m=1 nf=1
MN2 tl vbn avss avss nch W=wtail L=lcs m=2 nf=1
MP0 x1 x1 avdd avdd pch W='2*wp1' L=lmed m=2 nf=1
MP1 x2 x1 avdd avdd pch W='2*wp1' L=lmed m=2 nf=1
X0 x2 yb fcd_inv
X1 yb y fcd_inv4
.ends fca_c2c

*----------------------------------------------------------------------
* Library: FCL_ANA   Cell: fca_cl   View: schematic
*----------------------------------------------------------------------
.subckt fca_cl dp dn ckp ckn qp qn vbn avdd avss rl=800
R0 avdd qp 'rl'
R1 avdd qn 'rl'
MN0 qn dp ta avss nch_lvt W=wcml L=lmin m=1 nf=1
MN1 qp dn ta avss nch_lvt W=wcml L=lmin m=1 nf=1
MN2 qn qp tb avss nch_lvt W=wcml L=lmin m=1 nf=1
MN3 qp qn tb avss nch_lvt W=wcml L=lmin m=1 nf=1
MN4 ta ckp tc avss nch_lvt W='2*wcml' L=lmin m=1 nf=1
MN5 tb ckn tc avss nch_lvt W='2*wcml' L=lmin m=1 nf=1
MN6 tc vbn avss avss nch W=wtail L=lcs m=2 nf=1
.ends fca_cl

*----------------------------------------------------------------------
* Library: FCL_ANA   Cell: fca_clff   View: schematic
*----------------------------------------------------------------------
.subckt fca_clff dp dn ckp ckn qp qn vbn avdd avss
X0 dp dn ckn ckp mp mn vbn avdd avss fca_cl
X1 mp mn ckp ckn qp qn vbn avdd avss fca_cl
.ends fca_clff

*----------------------------------------------------------------------
* Library: FCL_ANA   Cell: fca_trm   View: schematic
*----------------------------------------------------------------------
.subckt fca_trm inp inn vcm avss
R0 inp vcm 50
R1 inn vcm 50
C0 vcm avss 2p
.ends fca_trm

*----------------------------------------------------------------------
* Library: FCL_ANA   Cell: fca_mix2w   View: schematic
*----------------------------------------------------------------------
.subckt fca_mix2w ap an bp bn w[1] w[0] wb[1] wb[0] outp outn vbn avdd avss rl=500
R0 avdd outp 'rl'
R1 avdd outn 'rl'
C0 outp avss 25f
C1 outn avss 25f
MN0 outn ap sa avss nch_lvt W=wcml L=lmin m=2 nf=1
MN1 outp an sa avss nch_lvt W=wcml L=lmin m=2 nf=1
MN2 outn bp sb avss nch_lvt W=wcml L=lmin m=2 nf=1
MN3 outp bn sb avss nch_lvt W=wcml L=lmin m=2 nf=1
MN4 sa vbn avss avss nch W=wtail L=lcs m=1 nf=1
MN5 sa wb[0] ka0 avss nch W=wsw L=lmin m=1 nf=1
MN6 ka0 vbn avss avss nch W=wtail L=lcs m=1 nf=1
MN7 sa wb[1] ka1 avss nch W=wsw L=lmin m=2 nf=1
MN8 ka1 vbn avss avss nch W=wtail L=lcs m=2 nf=1
MN9 sb w[0] kb0 avss nch W=wsw L=lmin m=1 nf=1
MN10 kb0 vbn avss avss nch W=wtail L=lcs m=1 nf=1
MN11 sb w[1] kb1 avss nch W=wsw L=lmin m=2 nf=1
MN12 kb1 vbn avss avss nch W=wtail L=lcs m=2 nf=1
.ends fca_mix2w

*----------------------------------------------------------------------
* Library: FCL_DLL   Cell: fca_dcell   View: schematic
*----------------------------------------------------------------------
.subckt fca_dcell inp inn outp outn vcn vcp avdd avss
MP0 x1 vcp avdd avdd pch W='2*wp1' L=lcs m=1 nf=1
MP1 outn inp x1 avdd pch W='2*wp1' L=lmin m=1 nf=1
MN1 outn inp y1 avss nch W='2*wn1' L=lmin m=1 nf=1
MN0 y1 vcn avss avss nch W='2*wn1' L=lcs m=1 nf=1
MP2 x2 vcp avdd avdd pch W='2*wp1' L=lcs m=1 nf=1
MP3 outp inn x2 avdd pch W='2*wp1' L=lmin m=1 nf=1
MN3 outp inn y2 avss nch W='2*wn1' L=lmin m=1 nf=1
MN2 y2 vcn avss avss nch W='2*wn1' L=lcs m=1 nf=1
MP4 outp outn avdd avdd pch W=wkp L=lcs m=1 nf=1
MN4 outp outn avss avss nch W=wkn L=lcs m=1 nf=1
MP5 outn outp avdd avdd pch W=wkp L=lcs m=1 nf=1
MN5 outn outp avss avss nch W=wkn L=lcs m=1 nf=1
.ends fca_dcell

*----------------------------------------------------------------------
* Library: FCL_DLL   Cell: fca_dline   View: schematic
*----------------------------------------------------------------------
.subckt fca_dline ckp ckn ph[7] ph[6] ph[5] ph[4] ph[3] ph[2] ph[1] ph[0] vcn vcp avdd avss
X0 ckp ckn ph[1] ph[5] vcn vcp avdd avss fca_dcell
X1 ph[1] ph[5] ph[2] ph[6] vcn vcp avdd avss fca_dcell
X2 ph[2] ph[6] ph[3] ph[7] vcn vcp avdd avss fca_dcell
X3 ph[3] ph[7] ph[4] ph[0] vcn vcp avdd avss fca_dcell
X4 ph[4] ph[0] dmp dmn vcn vcp avdd avss fca_dcell
.ends fca_dline

*----------------------------------------------------------------------
* Library: FCL_DLL   Cell: fca_pfd   View: schematic
*----------------------------------------------------------------------
.subckt fca_pfd ref fb rstb up upb dn dnb
MN0 refb ref vssd vssd nch W='2*wn1' L=lmin m=1 nf=1
MP0 refb ref vddd vddd pch W='2*wp1' L=lmin m=1 nf=1
MN1 fbb fb vssd vssd nch W='2*wn1' L=lmin m=1 nf=1
MP1 fbb fb vddd vddd pch W='2*wp1' L=lmin m=1 nf=1
X0 vddd ref refb rbd up upb fcd_dffr
X1 vddd fb fbb rbd dn dnb fcd_dffr
X2 up dn x0 fcd_nand2
X3 x0 x1 fcd_inv
X4 rstb rst fcd_inv
X5 x1 rst rbi fcd_nor2
X6 rbi r1 fcd_inv
X7 r1 rbd fcd_inv
.ends fca_pfd

*----------------------------------------------------------------------
* Library: FCL_DLL   Cell: fca_isw   View: schematic
*----------------------------------------------------------------------
.subckt fca_isw upb dn ib vctl avdd avss
MN0 ib ib avss avss nch W=wtail L=lcs m=2 nf=1
MN1 vbp ib avss avss nch W=wtail L=lcs m=2 nf=1
MP0 vbp vbp avdd avdd pch W='2*wtail' L=lcs m=2 nf=1
MP1 x vbp avdd avdd pch W='2*wtail' L=lcs m=2 nf=1
MP2 vctl upb x avdd pch W=wsw L=lmin m=1 nf=1
MN2 vctl dn y avss nch W=wsw L=lmin m=1 nf=1
MN3 y ib avss avss nch W=wtail L=lcs m=2 nf=1
.ends fca_isw

*----------------------------------------------------------------------
* Library: FCL_DLL   Cell: fca_lpf   View: schematic
*----------------------------------------------------------------------
.subckt fca_lpf vctl avss
R0 vctl lf1 4k
C0 lf1 avss 20p
C1 vctl avss 1.5p
.ends fca_lpf

*----------------------------------------------------------------------
* Library: FCL_DLL   Cell: fca_dll   View: schematic
*----------------------------------------------------------------------
.subckt fca_dll ckp ckn ph[7] ph[6] ph[5] ph[4] ph[3] ph[2] ph[1] ph[0] ib rstb vctl vcp
+ avdd avss
X0 ckp ckn ph[7] ph[6] ph[5] ph[4] ph[3] ph[2] ph[1] ph[0] vctl vcp avdd avss fca_dline
MN0 vcp vctl avss avss nch W='2*wn1' L=lcs m=2 nf=1
MP0 vcp vcp avdd avdd pch W='2*wp1' L=lcs m=2 nf=1
X1 ckp ph[0] rstb up upb dn dnb fca_pfd
X2 upb dn ib vctl avdd avss fca_isw
X3 vctl avss fca_lpf
MP1 vctl rstb avdd avdd pch W=wsw L=lmin m=1 nf=1
MN1 avss vctl avss avss nch W=4u L=1u m=4 nf=1
.ends fca_dll

*----------------------------------------------------------------------
* Library: FCL_DLL   Cell: fca_phd   View: schematic
*----------------------------------------------------------------------
.subckt fca_phd ph[7] ph[6] ph[5] ph[4] ph[3] ph[2] ph[1] ph[0] pho[7] pho[6] pho[5] pho[4]
+ pho[3] pho[2] pho[1] pho[0]
X0[7] ph[7] pho[3] fcd_inv4 m=2
X0[6] ph[6] pho[2] fcd_inv4 m=2
X0[5] ph[5] pho[1] fcd_inv4 m=2
X0[4] ph[4] pho[0] fcd_inv4 m=2
X0[3] ph[3] pho[7] fcd_inv4 m=2
X0[2] ph[2] pho[6] fcd_inv4 m=2
X0[1] ph[1] pho[5] fcd_inv4 m=2
X0[0] ph[0] pho[4] fcd_inv4 m=2
.ends fca_phd

*----------------------------------------------------------------------
* Library: FCL_DLL   Cell: fca_fwd   View: schematic
*----------------------------------------------------------------------
.subckt fca_fwd fckp fckn vcm vbn ib rstb pho[7] pho[6] pho[5] pho[4] pho[3] pho[2] pho[1]
+ pho[0] vctl vcp avdd avss
X0 fckp fckn vcm avss fca_trm
X1 fckp fckn fa_p fa_n vbn avdd avss fca_cmla rl=450
X2 fa_p fa_n ckp vbn avdd avss fca_c2c
X3 fa_n fa_p ckn vbn avdd avss fca_c2c
X4 ckp ckn ph[7] ph[6] ph[5] ph[4] ph[3] ph[2] ph[1] ph[0] ib rstb vctl vcp avdd avss
+ fca_dll
X5 ph[7] ph[6] ph[5] ph[4] ph[3] ph[2] ph[1] ph[0] pho[7] pho[6] pho[5] pho[4] pho[3] pho[2]
+ pho[1] pho[0] fca_phd
.ends fca_fwd

*----------------------------------------------------------------------
* Library: FCL_ANA   Cell: fca_bias   View: schematic
*----------------------------------------------------------------------
.subckt fca_bias ibias vbn_rx vbn_tx ib_cp vcm avdd avss
MN0 ibias ibias avss avss nch W=wtail L=lcs m=2 nf=1
MN1 n1 ibias avss avss nch W=wtail L=lcs m=4 nf=1
MP0 n1 n1 avdd avdd pch W='2*wtail' L=lcs m=4 nf=1
MP1 vbn_rx n1 avdd avdd pch W='2*wtail' L=lcs m=4 nf=1
MN2 vbn_rx vbn_rx avss avss nch W=wtail L=lcs m=4 nf=1
MP2 vbn_tx n1 avdd avdd pch W='2*wtail' L=lcs m=8 nf=1
MN3 vbn_tx vbn_tx avss avss nch W=wtail L=lcs m=4 nf=1
MP3 ib_cp n1 avdd avdd pch W='2*wtail' L=lcs m=1 nf=1
R0 avdd vcm 1k
R1 vcm avss 3k
C0 vcm avss 5p
.ends fca_bias

*----------------------------------------------------------------------
* Library: FCL_ESD   Cell: fce_lv   View: schematic
*----------------------------------------------------------------------
.subckt fce_lv pad avdd avss
MN0 pad avss avss avss nch W=wesd L=lmed m=4 nf=4
MP0 pad avdd avdd avdd pch W=wesd L=lmed m=4 nf=4
.ends fce_lv

*----------------------------------------------------------------------
* Library: FCL_ESD   Cell: fce_hv   View: schematic
*----------------------------------------------------------------------
.subckt fce_hv pad vddq vssq
MN0 pad vssq vssq vssq nch_hv W=whvesd L=lhv m=4 nf=4
MP0 pad vddq vddq vddq pch_hv W=whvesd L=lhv m=4 nf=4
.ends fce_hv

*----------------------------------------------------------------------
* Library: FCL_ESD   Cell: fce_clmp   View: schematic
*----------------------------------------------------------------------
.subckt fce_clmp vp vn
R0 vp rc 60k
C0 rc vn 2p
MN0 t1 rc vn vn nch W=wn1 L=lmed m=1 nf=1
MP0 t1 rc vp vp pch W=wp1 L=lmed m=1 nf=1
MN1 t2 t1 vn vn nch W='4*wn1' L=lmed m=1 nf=1
MP1 t2 t1 vp vp pch W='4*wp1' L=lmed m=1 nf=1
MN2 g t2 vn vn nch W='16*wn1' L=lmed m=1 nf=1
MP2 g t2 vp vp pch W='16*wp1' L=lmed m=1 nf=1
MN3 vp g vn vn nch W=20u L=lmed m=40 nf=20
.ends fce_clmp

*----------------------------------------------------------------------
* Library: FCL_ESD   Cell: fce_clmphv   View: schematic
*----------------------------------------------------------------------
.subckt fce_clmphv vp vn
R0 vp rc 60k
C0 rc vn 2p
MN0 t1 rc vn vn nch_hv W=whv L=lhv m=1 nf=1
MP0 t1 rc vp vp pch_hv W=whvp L=lhv m=1 nf=1
MN1 t2 t1 vn vn nch_hv W='4*whv' L=lhv m=1 nf=1
MP1 t2 t1 vp vp pch_hv W='4*whvp' L=lhv m=1 nf=1
MN2 g t2 vn vn nch_hv W='16*whv' L=lhv m=1 nf=1
MP2 g t2 vp vp pch_hv W='16*whvp' L=lhv m=1 nf=1
MN3 vp g vn vn nch_hv W=40u L=lhv m=40 nf=20
.ends fce_clmphv

*----------------------------------------------------------------------
* Library: FCL_RX   Cell: fcr_phsel   View: schematic
*----------------------------------------------------------------------
.subckt fcr_phsel ph[7] ph[6] ph[5] ph[4] ph[3] ph[2] ph[1] ph[0] k[2] k[1] k[0] a ab b bb
X0[2] k[2] kb[2] fcd_inv
X0[1] k[1] kb[1] fcd_inv
X0[0] k[0] kb[0] fcd_inv
X1[3] ph[6] ph[7] k[0] kb[0] ta1[3] fcd_tgmux
X1[2] ph[4] ph[5] k[0] kb[0] ta1[2] fcd_tgmux
X1[1] ph[2] ph[3] k[0] kb[0] ta1[1] fcd_tgmux
X1[0] ph[0] ph[1] k[0] kb[0] ta1[0] fcd_tgmux
X2[1] ta1[2] ta1[3] k[1] kb[1] ta2[1] fcd_tgmux
X2[0] ta1[0] ta1[1] k[1] kb[1] ta2[0] fcd_tgmux
X3 ta2[0] ta2[1] k[2] kb[2] ta fcd_tgmux
X4[3] ph[7] ph[0] k[0] kb[0] tb1[3] fcd_tgmux
X4[2] ph[5] ph[6] k[0] kb[0] tb1[2] fcd_tgmux
X4[1] ph[3] ph[4] k[0] kb[0] tb1[1] fcd_tgmux
X4[0] ph[1] ph[2] k[0] kb[0] tb1[0] fcd_tgmux
X5[1] tb1[2] tb1[3] k[1] kb[1] tb2[1] fcd_tgmux
X5[0] tb1[0] tb1[1] k[1] kb[1] tb2[0] fcd_tgmux
X6 tb2[0] tb2[1] k[2] kb[2] tb fcd_tgmux
X7 ta ab fcd_inv
X8 ab a fcd_inv4
X9 tb bb fcd_inv
X10 bb b fcd_inv4
.ends fcr_phsel

*----------------------------------------------------------------------
* Library: FCL_RX   Cell: fcr_phmix   View: schematic
*----------------------------------------------------------------------
.subckt fcr_phmix ph[7] ph[6] ph[5] ph[4] ph[3] ph[2] ph[1] ph[0] code[4] code[3] code[2]
+ code[1] code[0] codeb[1] codeb[0] ckp ckn vbn avdd avss
X0 ph[7] ph[6] ph[5] ph[4] ph[3] ph[2] ph[1] ph[0] code[4] code[3] code[2] a ab b bb
+ fcr_phsel
X1 a ab b bb code[1] code[0] codeb[1] codeb[0] ckp ckn vbn avdd avss fca_mix2w rl=420
.ends fcr_phmix

*----------------------------------------------------------------------
* Library: FCL_RX   Cell: fcr_smp   View: schematic
*----------------------------------------------------------------------
.subckt fcr_smp dp dn ckp ckn vbn dsam esam avdd avss
X0 dp dn ckp ckn dqp dqn vbn avdd avss fca_clff
X1 dp dn ckn ckp eqp eqn vbn avdd avss fca_clff
X2 dqp dqn dsam vbn avdd avss fca_c2c
X3 eqp eqn esam vbn avdd avss fca_c2c
.ends fcr_smp

*----------------------------------------------------------------------
* Library: FCL_RX   Cell: fcr_bbx   View: schematic
*----------------------------------------------------------------------
.subckt fcr_bbx dsam esam ck ckb s0 s1 up dn
X0 dsam ckb ck s0 s0b fcd_dff
X1 s0 ckb ck s1 s1b fcd_dff
X2 esam ck ckb e0 e0b fcd_dff
X3 e0 ckb ck e1 e1b fcd_dff
X4 e1 s0 up fcd_xor2
X5 s1 e1 dn fcd_xor2
.ends fcr_bbx

*----------------------------------------------------------------------
* Library: FCL_RX   Cell: fcr_vote   View: schematic
*----------------------------------------------------------------------
.subckt fcr_vote up dn ck ckb vub vdb
X0 up ck ckb u1 u1b fcd_dff
X1 u1 ck ckb u2 u2b fcd_dff
X2 dn ck ckb d1 d1b fcd_dff
X3 d1 ck ckb d2 d2b fcd_dff
X4 up u1 u2 vub fcd_majb3
X5 dn d1 d2 vdb fcd_majb3
.ends fcr_vote

*----------------------------------------------------------------------
* Library: FCL_RX   Cell: fcr_ube   View: schematic
*----------------------------------------------------------------------
.subckt fcr_ube cu cd ck ckb rb q qb cuob cdob
X0 qn ck ckb rb q qb fcd_dffr
MN0 tb cu vssd vssd nch W=wn1 L=lmin m=1 nf=1
MN1 tb cd vssd vssd nch W=wn1 L=lmin m=1 nf=1
MP0 n0 cu vddd vddd pch W='2*wp1' L=lmin m=1 nf=1
MP1 tb cd n0 vddd pch W='2*wp1' L=lmin m=1 nf=1
X1 qb tb qn fcd_xor2
MN2 cuob cu n1 vssd nch W='2*wn1' L=lmin m=1 nf=1
MN3 n1 q vssd vssd nch W='2*wn1' L=lmin m=1 nf=1
MP2 cuob cu vddd vddd pch W=wp1 L=lmin m=1 nf=1
MP3 cuob q vddd vddd pch W=wp1 L=lmin m=1 nf=1
MN4 cdob cd n2 vssd nch W='2*wn1' L=lmin m=1 nf=1
MN5 n2 qb vssd vssd nch W='2*wn1' L=lmin m=1 nf=1
MP4 cdob cd vddd vddd pch W=wp1 L=lmin m=1 nf=1
MP5 cdob qb vddd vddd pch W=wp1 L=lmin m=1 nf=1
.ends fcr_ube

*----------------------------------------------------------------------
* Library: FCL_RX   Cell: fcr_ubo   View: schematic
*----------------------------------------------------------------------
.subckt fcr_ubo cub cdb ck ckb rb q qb cuo cdo
X0 qn ck ckb rb q qb fcd_dffr
MN0 t cub n0 vssd nch W='2*wn1' L=lmin m=1 nf=1
MN1 n0 cdb vssd vssd nch W='2*wn1' L=lmin m=1 nf=1
MP0 t cub vddd vddd pch W=wp1 L=lmin m=1 nf=1
MP1 t cdb vddd vddd pch W=wp1 L=lmin m=1 nf=1
X1 q t qn fcd_xor2
MN2 cuo cub vssd vssd nch W=wn1 L=lmin m=1 nf=1
MN3 cuo qb vssd vssd nch W=wn1 L=lmin m=1 nf=1
MP2 n1 cub vddd vddd pch W='2*wp1' L=lmin m=1 nf=1
MP3 cuo qb n1 vddd pch W='2*wp1' L=lmin m=1 nf=1
MN4 cdo cdb vssd vssd nch W=wn1 L=lmin m=1 nf=1
MN5 cdo q vssd vssd nch W=wn1 L=lmin m=1 nf=1
MP4 n2 cdb vddd vddd pch W='2*wp1' L=lmin m=1 nf=1
MP5 cdo q n2 vddd pch W='2*wp1' L=lmin m=1 nf=1
.ends fcr_ubo

*----------------------------------------------------------------------
* Library: FCL_RX   Cell: fcr_acc   View: schematic
*----------------------------------------------------------------------
.subckt fcr_acc vub vdb hold rb ck ckb code[4] code[3] code[2] code[1] code[0] codeb[1]
+ codeb[0]
X0 hold holdb fcd_inv
X1 vdb holdb x0 fcd_nand2
X2 vub x0 u fcd_nor2
X3 vub holdb x1 fcd_nand2
X4 vdb x1 d fcd_nor2
X5 u d ck ckb rb code[0] codeb[0] cub1 cdb1 fcr_ube
X6 cub1 cdb1 ck ckb rb code[1] codeb[1] cu2 cd2 fcr_ubo
X7 cu2 cd2 ck ckb rb code[2] cb2 cub3 cdb3 fcr_ube
X8 cub3 cdb3 ck ckb rb code[3] cb3 cu4 cd4 fcr_ubo
X9 cu4 cd4 ck ckb rb code[4] cb4 cub5 cdb5 fcr_ube
.ends fcr_acc

*----------------------------------------------------------------------
* Library: FCL_RX   Cell: fcr_jdiv8   View: schematic
*----------------------------------------------------------------------
.subckt fcr_jdiv8 ck ckb rb wck wckb ld ldb
X0 wckb ck ckb rb q0 q0b fcd_dffr
X1 q0 ck ckb rb q1 q1b fcd_dffr
X2 q1 ck ckb rb q2 q2b fcd_dffr
X3 q2 ck ckb rb wck wckb fcd_dffr
X4 q0 q1b ldb fcd_nand2
MN0 ld ldb vssd vssd nch W='2*wn1' L=lmin m=1 nf=1
MP0 ld ldb vddd vddd pch W='2*wp1' L=lmin m=1 nf=1
.ends fcr_jdiv8

*----------------------------------------------------------------------
* Library: FCL_RX   Cell: fcr_dsr8   View: schematic
*----------------------------------------------------------------------
.subckt fcr_dsr8 sr[1] sr[0] ck ckb ld ldb rxd[7] rxd[6] rxd[5] rxd[4] rxd[3] rxd[2] rxd[1]
+ rxd[0]
X0[7] sr[6] ck ckb sr[7] srb[7] fcd_dff
X0[6] sr[5] ck ckb sr[6] srb[6] fcd_dff
X0[5] sr[4] ck ckb sr[5] srb[5] fcd_dff
X0[4] sr[3] ck ckb sr[4] srb[4] fcd_dff
X0[3] sr[2] ck ckb sr[3] srb[3] fcd_dff
X0[2] sr[1] ck ckb sr[2] srb[2] fcd_dff
X1[7] sr[7] ld ldb rxd[0] fcd_lat
X1[6] sr[6] ld ldb rxd[1] fcd_lat
X1[5] sr[5] ld ldb rxd[2] fcd_lat
X1[4] sr[4] ld ldb rxd[3] fcd_lat
X1[3] sr[3] ld ldb rxd[4] fcd_lat
X1[2] sr[2] ld ldb rxd[5] fcd_lat
X1[1] sr[1] ld ldb rxd[6] fcd_lat
X1[0] sr[0] ld ldb rxd[7] fcd_lat
.ends fcr_dsr8

*----------------------------------------------------------------------
* Library: FCL_RX   Cell: fcr_dig   View: schematic
*----------------------------------------------------------------------
.subckt fcr_dig dsam esam ck rb hold rxd[7] rxd[6] rxd[5] rxd[4] rxd[3] rxd[2] rxd[1] rxd[0]
+ wck code[4] code[3] code[2] code[1] code[0] codeb[1] codeb[0]
X0 ck cka ckab fcd_ckbuf m=2
X1 dsam esam cka ckab sr[0] sr[1] up dn fcr_bbx
X2 up dn ckab cka vub vdb fcr_vote
X3 sr[1] sr[0] ckab cka ld ldb rxd[7] rxd[6] rxd[5] rxd[4] rxd[3] rxd[2] rxd[1] rxd[0]
+ fcr_dsr8
X4 cka ckab rb wck wckb ld ldb fcr_jdiv8
X5 vub vdb hold rb wck wckb code[4] code[3] code[2] code[1] code[0] codeb[1] codeb[0]
+ fcr_acc
.ends fcr_dig

*----------------------------------------------------------------------
* Library: FCL_RX   Cell: fcr_lane   View: schematic
*----------------------------------------------------------------------
.subckt fcr_lane rxp rxn vcm vbn ph[7] ph[6] ph[5] ph[4] ph[3] ph[2] ph[1] ph[0] rb hold
+ rxd[7] rxd[6] rxd[5] rxd[4] rxd[3] rxd[2] rxd[1] rxd[0] wck code[4] code[3] code[2]
+ code[1] code[0] avdd avss
X0 rxp rxn vcm avss fca_trm
X1 rxp rxn la_p la_n vbn avdd avss fca_cmla
X2 la_p la_n pck_p pck_n vbn dsam esam avdd avss fcr_smp
X3 ph[7] ph[6] ph[5] ph[4] ph[3] ph[2] ph[1] ph[0] code[4] code[3] code[2] code[1] code[0]
+ codeb[1] codeb[0] pck_p pck_n vbn avdd avss fcr_phmix
X4 pck_p pck_n ck vbn avdd avss fca_c2c
X5 dsam esam ck rb hold rxd[7] rxd[6] rxd[5] rxd[4] rxd[3] rxd[2] rxd[1] rxd[0] wck code[4]
+ code[3] code[2] code[1] code[0] codeb[1] codeb[0] fcr_dig
.ends fcr_lane

*----------------------------------------------------------------------
* Library: FCL_TX   Cell: fca_tleg   View: schematic
*----------------------------------------------------------------------
.subckt fca_tleg s en vbn avss
MN0 s en k avss nch W=wsw L=lmin m=1 nf=1
MN1 k vbn avss avss nch W=wtail L=lcs m=1 nf=1
.ends fca_tleg

*----------------------------------------------------------------------
* Library: FCL_TX   Cell: fcx_ser8   View: schematic
*----------------------------------------------------------------------
.subckt fcx_ser8 txd[7] txd[6] txd[5] txd[4] txd[3] txd[2] txd[1] txd[0] ck ckb ld ldb so
X0[7] vssd txd[7] ld ldb mx[7] fcd_tgmux
X0[6] sq[7] txd[6] ld ldb mx[6] fcd_tgmux
X0[5] sq[6] txd[5] ld ldb mx[5] fcd_tgmux
X0[4] sq[5] txd[4] ld ldb mx[4] fcd_tgmux
X0[3] sq[4] txd[3] ld ldb mx[3] fcd_tgmux
X0[2] sq[3] txd[2] ld ldb mx[2] fcd_tgmux
X0[1] sq[2] txd[1] ld ldb mx[1] fcd_tgmux
X0[0] sq[1] txd[0] ld ldb mx[0] fcd_tgmux
X1[7] mx[7] ck ckb sq[7] sqb[7] fcd_dff
X1[6] mx[6] ck ckb sq[6] sqb[6] fcd_dff
X1[5] mx[5] ck ckb sq[5] sqb[5] fcd_dff
X1[4] mx[4] ck ckb sq[4] sqb[4] fcd_dff
X1[3] mx[3] ck ckb sq[3] sqb[3] fcd_dff
X1[2] mx[2] ck ckb sq[2] sqb[2] fcd_dff
X1[1] mx[1] ck ckb sq[1] sqb[1] fcd_dff
X1[0] mx[0] ck ckb sq[0] sqb[0] fcd_dff
X2 sq[0] so sob fcd_ckbuf
.ends fcx_ser8

*----------------------------------------------------------------------
* Library: FCL_TX   Cell: fcx_ffe   View: schematic
*----------------------------------------------------------------------
.subckt fcx_ffe so ck ckb pre preb main mainb post postb
X0 so ck ckb d1 d1b fcd_dff
X1 d1 ck ckb d2 d2b fcd_dff
X2 so pre preb fcd_ckbuf
X3 d1 main mainb fcd_ckbuf m=2
X4 d2 post postb fcd_ckbuf
.ends fcx_ffe

*----------------------------------------------------------------------
* Library: FCL_TX   Cell: fcx_drv   View: schematic
*----------------------------------------------------------------------
.subckt fcx_drv pre preb main mainb post postb wpre[1] wpre[0] wmain[3] wmain[2] wmain[1]
+ wmain[0] wpost[2] wpost[1] wpost[0] txp txn vbn avdd avss
R0 avdd txp 50
R1 avdd txn 50
MN0 txn main sm avss nch_lvt W=wcml L=lmin m=8 nf=4
MN1 txp mainb sm avss nch_lvt W=wcml L=lmin m=8 nf=4
MN2 txp pre sp avss nch_lvt W=wcml L=lmin m=2 nf=2
MN3 txn preb sp avss nch_lvt W=wcml L=lmin m=2 nf=2
MN4 txp post sq avss nch_lvt W=wcml L=lmin m=4 nf=2
MN5 txn postb sq avss nch_lvt W=wcml L=lmin m=4 nf=2
X0 sm wmain[0] vbn avss fca_tleg m=1
X1 sm wmain[1] vbn avss fca_tleg m=2
X2 sm wmain[2] vbn avss fca_tleg m=4
X3 sm wmain[3] vbn avss fca_tleg m=8
X4 sp wpre[0] vbn avss fca_tleg m=1
X5 sp wpre[1] vbn avss fca_tleg m=2
X6 sq wpost[0] vbn avss fca_tleg m=1
X7 sq wpost[1] vbn avss fca_tleg m=2
X8 sq wpost[2] vbn avss fca_tleg m=4
.ends fcx_drv

*----------------------------------------------------------------------
* Library: FCL_TX   Cell: fcx_lane   View: schematic
*----------------------------------------------------------------------
.subckt fcx_lane txd[7] txd[6] txd[5] txd[4] txd[3] txd[2] txd[1] txd[0] ck rb wpre[1]
+ wpre[0] wmain[3] wmain[2] wmain[1] wmain[0] wpost[2] wpost[1] wpost[0] txp txn wck vbn
+ avdd avss
X0 ck cka ckab fcd_ckbuf m=2
X1 cka ckab rb wck wckb ld ldb fcr_jdiv8
X2 txd[7] txd[6] txd[5] txd[4] txd[3] txd[2] txd[1] txd[0] cka ckab ld ldb so fcx_ser8
X3 so cka ckab pre preb main mainb post postb fcx_ffe
X4 pre preb main mainb post postb wpre[1] wpre[0] wmain[3] wmain[2] wmain[1] wmain[0]
+ wpost[2] wpost[1] wpost[0] txp txn vbn avdd avss fcx_drv
.ends fcx_lane

*----------------------------------------------------------------------
* Library: FCL_TST   Cell: fct_csi   View: schematic
*----------------------------------------------------------------------
.subckt fct_csi a y vcn vcp avdd avss
MP0 x vcp avdd avdd pch W='2*wp1' L=lcs m=1 nf=1
MP1 y a x avdd pch W='2*wp1' L=lmin m=1 nf=1
MN1 y a z avss nch W='2*wn1' L=lmin m=1 nf=1
MN0 z vcn avss avss nch W='2*wn1' L=lcs m=1 nf=1
.ends fct_csi

*----------------------------------------------------------------------
* Library: FCL_TST   Cell: fct_cs5   View: schematic
*----------------------------------------------------------------------
.subckt fct_cs5 en y vcn vcp avdd avss
MP0 x0 vcp avdd avdd pch W='2*wp1' L=lcs m=1 nf=1
MP1 r0 r4 x0 avdd pch W='2*wp1' L=lmin m=1 nf=1
MP2 r0 en avdd avdd pch W=wp1 L=lmin m=1 nf=1
MN1 r0 r4 n0 avss nch W='2*wn1' L=lmin m=1 nf=1
MN2 n0 en n1 avss nch W='2*wn1' L=lmin m=1 nf=1
MN0 n1 vcn avss avss nch W='2*wn1' L=lcs m=1 nf=1
X0 r0 r1 vcn vcp avdd avss fct_csi
X1 r1 r2 vcn vcp avdd avss fct_csi
X2 r2 r3 vcn vcp avdd avss fct_csi
X3 r3 r4 vcn vcp avdd avss fct_csi
MN3 y r4 avss avss nch W=wn1 L=lmin m=1 nf=1
MP3 y r4 avdd avdd pch W=wp1 L=lmin m=1 nf=1
.ends fct_cs5

*----------------------------------------------------------------------
* Library: FCL_TST   Cell: fct_rip3   View: schematic
*----------------------------------------------------------------------
.subckt fct_rip3 ck ckb rb q[2] q[1] q[0] qb[2] qb[1] qb[0]
X0 qb[0] ck ckb rb q[0] qb[0] fcd_dffr
X1 qb[1] qb[0] q[0] rb q[1] qb[1] fcd_dffr
X2 qb[2] qb[1] q[1] rb q[2] qb[2] fcd_dffr
.ends fct_rip3

*----------------------------------------------------------------------
* Library: FCL_TST   Cell: fct_mon   View: schematic
*----------------------------------------------------------------------
.subckt fct_mon en gate rb vcn vcp rodiv cnt[5] cnt[4] cnt[3] cnt[2] cnt[1] cnt[0] avdd avss
X0 en rclk vcn vcp avdd avss fct_cs5
X1 rclk rca rcab fcd_ckbuf
X2 rca rcab rb dq[2] dq[1] dq[0] dqb[2] dqb[1] dqb[0] fct_rip3
X3 dq[2] t0 fcd_inv
X4 t0 rodiv fcd_inv4
X5 gate dq[2] gckb fcd_nand2
X6 gckb gck fcd_inv
X7 gck gckb rb cnt[2] cnt[1] cnt[0] cb[2] cb[1] cb[0] fct_rip3
X8 cb[2] cnt[2] rb cnt[5] cnt[4] cnt[3] cb[5] cb[4] cb[3] fct_rip3
.ends fct_mon

*----------------------------------------------------------------------
* Library: FCL_SIO   Cell: fcs_inrx   View: schematic
*----------------------------------------------------------------------
.subckt fcs_inrx pad o vddq vssq
X0 pad vddq vssq fce_hv
R0 pad pi 200
MN5 pi vssq vssq vssq nch_hv W='4*whv' L=lhv m=1 nf=1
MP0 p1 pi vddq vddq pch_hv W=whvp L=lhv m=1 nf=1
MP1 sx pi p1 vddq pch_hv W=whvp L=lhv m=1 nf=1
MN1 sx pi n1 vssq nch_hv W=whv L=lhv m=1 nf=1
MN2 n1 pi vssq vssq nch_hv W=whv L=lhv m=1 nf=1
MP2 p1 sx vssq vddq pch_hv W='0.5*whvp' L=lhv m=1 nf=1
MN3 n1 sx vddq vssq nch_hv W='0.5*whv' L=lhv m=1 nf=1
MN4 o sx vssd vssd nch_hv W=whv L=lhv m=1 nf=1
MP4 o sx vddd vddd pch_hv W=whvp L=lhv m=1 nf=1
.ends fcs_inrx

*----------------------------------------------------------------------
* Library: FCL_SIO   Cell: fcs_creg   View: schematic
*----------------------------------------------------------------------
.subckt fcs_creg ci[3] ci[2] ci[1] ci[0] stb rb cq[3] cq[2] cq[1] cq[0]
X0 stb sk skb fcd_ckbuf
X1[3] ci[3] sk skb rb cq[3] cqb[3] fcd_dffr
X1[2] ci[2] sk skb rb cq[2] cqb[2] fcd_dffr
X1[1] ci[1] sk skb rb cq[1] cqb[1] fcd_dffr
X1[0] ci[0] sk skb rb cq[0] cqb[0] fcd_dffr
.ends fcs_creg

*----------------------------------------------------------------------
* Library: FCL_SIO   Cell: fcs_pads   View: schematic
*----------------------------------------------------------------------
.subckt fcs_pads cpad[3] cpad[2] cpad[1] cpad[0] spad rb cq[3] cq[2] cq[1] cq[0] vddq vssq
X0[3] cpad[3] ci[3] vddq vssq fcs_inrx
X0[2] cpad[2] ci[2] vddq vssq fcs_inrx
X0[1] cpad[1] ci[1] vddq vssq fcs_inrx
X0[0] cpad[0] ci[0] vddq vssq fcs_inrx
X1 spad si vddq vssq fcs_inrx
X2 ci[3] ci[2] ci[1] ci[0] si rb cq[3] cq[2] cq[1] cq[0] fcs_creg
.ends fcs_pads

*----------------------------------------------------------------------
* Library: FCL_TOP   Cell: fcl_link_top   View: schematic
*----------------------------------------------------------------------
.subckt fcl_link_top fck_p fck_n rx_p[3] rx_p[2] rx_p[1] rx_p[0] rx_n[3] rx_n[2] rx_n[1]
+ rx_n[0] tx_p tx_n cmd_pad[3] cmd_pad[2] cmd_pad[1] cmd_pad[0] cstb_pad rxd[31] rxd[30]
+ rxd[29] rxd[28] rxd[27] rxd[26] rxd[25] rxd[24] rxd[23] rxd[22] rxd[21] rxd[20] rxd[19]
+ rxd[18] rxd[17] rxd[16] rxd[15] rxd[14] rxd[13] rxd[12] rxd[11] rxd[10] rxd[9] rxd[8]
+ rxd[7] rxd[6] rxd[5] rxd[4] rxd[3] rxd[2] rxd[1] rxd[0] rx_wck[3] rx_wck[2] rx_wck[1]
+ rx_wck[0] rx_pic[19] rx_pic[18] rx_pic[17] rx_pic[16] rx_pic[15] rx_pic[14] rx_pic[13]
+ rx_pic[12] rx_pic[11] rx_pic[10] rx_pic[9] rx_pic[8] rx_pic[7] rx_pic[6] rx_pic[5]
+ rx_pic[4] rx_pic[3] rx_pic[2] rx_pic[1] rx_pic[0] txd[7] txd[6] txd[5] txd[4] txd[3]
+ txd[2] txd[1] txd[0] tx_wck txffe_pre[1] txffe_pre[0] txffe_main[3] txffe_main[2]
+ txffe_main[1] txffe_main[0] txffe_post[2] txffe_post[1] txffe_post[0] ro_div ro_cnt[5]
+ ro_cnt[4] ro_cnt[3] ro_cnt[2] ro_cnt[1] ro_cnt[0] cmd_q[3] cmd_q[2] cmd_q[1] cmd_q[0]
+ rst_n dll_rst_n fc_rst_n ibias dll_vmon avdd avss vddq vssq
X0 ibias vbn_rx vbn_tx ib_cp vcm avdd avss fca_bias
X1 fck_p fck_n vcm vbn_rx ib_cp dll_rst_n ph[7] ph[6] ph[5] ph[4] ph[3] ph[2] ph[1] ph[0]
+ vctl vcp avdd avss fca_fwd
X2[3] rx_p[3] rx_n[3] vcm vbn_rx ph[7] ph[6] ph[5] ph[4] ph[3] ph[2] ph[1] ph[0] rst_n
+ cmd_q[1] rxd[31] rxd[30] rxd[29] rxd[28] rxd[27] rxd[26] rxd[25] rxd[24] rx_wck[3]
+ rx_pic[19] rx_pic[18] rx_pic[17] rx_pic[16] rx_pic[15] avdd avss fcr_lane
X2[2] rx_p[2] rx_n[2] vcm vbn_rx ph[7] ph[6] ph[5] ph[4] ph[3] ph[2] ph[1] ph[0] rst_n
+ cmd_q[1] rxd[23] rxd[22] rxd[21] rxd[20] rxd[19] rxd[18] rxd[17] rxd[16] rx_wck[2]
+ rx_pic[14] rx_pic[13] rx_pic[12] rx_pic[11] rx_pic[10] avdd avss fcr_lane
X2[1] rx_p[1] rx_n[1] vcm vbn_rx ph[7] ph[6] ph[5] ph[4] ph[3] ph[2] ph[1] ph[0] rst_n
+ cmd_q[1] rxd[15] rxd[14] rxd[13] rxd[12] rxd[11] rxd[10] rxd[9] rxd[8] rx_wck[1] rx_pic[9]
+ rx_pic[8] rx_pic[7] rx_pic[6] rx_pic[5] avdd avss fcr_lane
X2[0] rx_p[0] rx_n[0] vcm vbn_rx ph[7] ph[6] ph[5] ph[4] ph[3] ph[2] ph[1] ph[0] rst_n
+ cmd_q[1] rxd[7] rxd[6] rxd[5] rxd[4] rxd[3] rxd[2] rxd[1] rxd[0] rx_wck[0] rx_pic[4]
+ rx_pic[3] rx_pic[2] rx_pic[1] rx_pic[0] avdd avss fcr_lane
X3 txd[7] txd[6] txd[5] txd[4] txd[3] txd[2] txd[1] txd[0] ph[0] rst_n txffe_pre[1]
+ txffe_pre[0] txffe_main[3] txffe_main[2] txffe_main[1] txffe_main[0] txffe_post[2]
+ txffe_post[1] txffe_post[0] tx_p tx_n tx_wck vbn_tx avdd avss fcx_lane
X4 cmd_q[0] cmd_q[2] fc_rst_n vctl vcp ro_div ro_cnt[5] ro_cnt[4] ro_cnt[3] ro_cnt[2]
+ ro_cnt[1] ro_cnt[0] avdd avss fct_mon
X5 cmd_pad[3] cmd_pad[2] cmd_pad[1] cmd_pad[0] cstb_pad rst_n cmd_q[3] cmd_q[2] cmd_q[1]
+ cmd_q[0] vddq vssq fcs_pads
X6 fck_p avdd avss fce_lv
X7 fck_n avdd avss fce_lv
X8[3] rx_p[3] avdd avss fce_lv
X8[2] rx_p[2] avdd avss fce_lv
X8[1] rx_p[1] avdd avss fce_lv
X8[0] rx_p[0] avdd avss fce_lv
X9[3] rx_n[3] avdd avss fce_lv
X9[2] rx_n[2] avdd avss fce_lv
X9[1] rx_n[1] avdd avss fce_lv
X9[0] rx_n[0] avdd avss fce_lv
X10 tx_p avdd avss fce_lv
X11 tx_n avdd avss fce_lv
X12 avdd avss fce_clmp
X13 vddd vssd fce_clmp
X14 vddq vssq fce_clmphv
R0 vctl dll_vmon 20k
C0 avdd avss 20p
.ends fcl_link_top

.end
